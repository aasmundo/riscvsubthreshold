// Design: power_gating_fine/alu_sym
simulator lang=spectre
global 0 vdd gnds vdds VDD GND
//include "models.scs"
include "/home/aasmundo/1_corners.scs"

// S28_coreLVTPB4_AFBB/LVT_NADN2x1_PB4_AFBB/schematic
subckt LVT_NADN2x1_PB4_AFBB A B Z inh_gnd inh_gnds inh_vdd inh_vdds
    N1 (net10 A inh_gnd inh_gnds) lvtnfet w=400n l=30.00n nf=(1)*(1) ngcon=1 nsig_delvto_uo1=0 nsig_delvto_uo2=0 soa=1 swshe=0 swacc=-1 swrg=-1 swrsub=-1 mismatch=1 m=1
    N0 (Z B net10 inh_gnds) lvtnfet w=400n l=30.00n nf=(1)*(1) ngcon=1 nsig_delvto_uo1=0 nsig_delvto_uo2=0 soa=1 swshe=0 swacc=-1 swrg=-1 swrsub=-1 mismatch=1 m=1
    P0 (Z A inh_vdd inh_vdds) lvtpfet w=260n l=30.00n nf=(1)*(1) ngcon=1 nsig_delvto_uo1=0 nsig_delvto_uo2=0 soa=1 swshe=0 swacc=-1 swrg=-1 swrsub=-1 mismatch=1 m=1
    P1 (Z B inh_vdd inh_vdds) lvtpfet w=260n l=30n nf=(1)*(1) ngcon=1 nsig_delvto_uo1=0 nsig_delvto_uo2=0 soa=1 swshe=0 swacc=-1 swrg=-1 swrsub=-1 mismatch=1 m=1
ends LVT_NADN2x1_PB4_AFBB

// S28_coreLVTPB4_AFBB/LVT_invx2_PB4_AFBB/schematic
subckt LVT_invx2_PB4_AFBB in out inh_gnd inh_gnds inh_vdd inh_vdds
    N1 (out in inh_gnd inh_gnds) lvtnfet w=400n l=30.00n nf=(2)*(1) ngcon=1 nsig_delvto_uo1=0 nsig_delvto_uo2=0 soa=1 swshe=0 swacc=0 swrg=0 swrsub=0 mismatch=1 m=1
    P1 (out in inh_vdd inh_vdds) lvtpfet w=550n l=30.00n nf=(2)*(1) ngcon=1 nsig_delvto_uo1=0 nsig_delvto_uo2=0 soa=1 swshe=0 swacc=0 swrg=0 swrsub=0 mismatch=1 m=1
ends LVT_invx2_PB4_AFBB

// S28_coreLVTPB4_AFBB/LVT_NOR2x1_PB4_AFBB/schematic
subckt LVT_NOR2x1_PB4_AFBB A B Z inh_gnd inh_gnds inh_vdd inh_vdds
    N0 (Z A inh_gnd inh_gnds) lvtnfet w=200n l=30.00n nf=(1)*(1) ngcon=1 nsig_delvto_uo1=0 nsig_delvto_uo2=0 soa=1 swshe=0 swacc=-1 swrg=-1 swrsub=-1 mismatch=1 m=1
    N1 (Z B inh_gnd inh_gnds) lvtnfet w=200n l=30.00n nf=(1)*(1) ngcon=1 nsig_delvto_uo1=0 nsig_delvto_uo2=0 soa=1 swshe=0 swacc=-1 swrg=-1 swrsub=-1 mismatch=1 m=1
    P0 (net10 A inh_vdd inh_vdds) lvtpfet w=460n l=30.00n nf=(1)*(1) ngcon=1 nsig_delvto_uo1=0 nsig_delvto_uo2=0 soa=1 swshe=0 swacc=-1 swrg=-1 swrsub=-1 mismatch=1 m=1
    P1 (Z B net10 inh_vdds) lvtpfet w=460n l=30.00n nf=(1)*(1) ngcon=1 nsig_delvto_uo1=0 nsig_delvto_uo2=0 soa=1 swshe=0 swacc=-1 swrg=-1 swrsub=-1 mismatch=1 m=1
ends LVT_NOR2x1_PB4_AFBB

// S28_coreLVTPB4_AFBB/LVT_BUFx1_PB4_AFBB/schematic
subckt LVT_BUFx1_PB4_AFBB in out inh_gnd inh_gnds inh_vdd inh_vdds
    N0 (out net8 inh_gnd inh_gnds) lvtnfet w=200n l=30.00n nf=(1)*(1) ngcon=1 nsig_delvto_uo1=0 nsig_delvto_uo2=0 soa=1 swshe=0 swacc=0 swrg=0 swrsub=0 mismatch=1 m=1
    N1 (net8 in inh_gnd inh_gnds) lvtnfet w=200n l=30.00n nf=(1)*(1) ngcon=1 nsig_delvto_uo1=0 nsig_delvto_uo2=0 soa=1 swshe=0 swacc=0 swrg=0 swrsub=0 mismatch=1 m=1
    P0 (out net8 inh_vdd inh_vdds) lvtpfet w=275n l=30.00n nf=(1)*(1) ngcon=1 nsig_delvto_uo1=0 nsig_delvto_uo2=0 soa=1 swshe=0 swacc=0 swrg=0 swrsub=0 mismatch=1 m=1
    P1 (net8 in inh_vdd inh_vdds) lvtpfet w=275n l=30.00n nf=(1)*(1) ngcon=1 nsig_delvto_uo1=0 nsig_delvto_uo2=0 soa=1 swshe=0 swacc=0 swrg=0 swrsub=0 mismatch=1 m=1
ends LVT_BUFx1_PB4_AFBB

// S28_coreLVTPB4_AFBB/LVT_FAx1_PB4_AFBB/schematic
subckt LVT_FAx1_PB4_AFBB A B Cin Cout sum inh_gnd inh_gnds inh_vdd inh_vdds
    N16 (net047 net04 inh_gnd inh_gnds) lvtnfet w=200n l=30.00n nf=(1)*(1) ngcon=1 nsig_delvto_uo1=0 nsig_delvto_uo2=0 soa=1 swshe=0 swacc=-1 swrg=-1 swrsub=-1 mismatch=1 m=1
    N15 (net028 net08 inh_gnd inh_gnds) lvtnfet w=200n l=30.00n nf=(1)*(1) ngcon=1 nsig_delvto_uo1=0 nsig_delvto_uo2=0 soa=1 swshe=0 swacc=-1 swrg=-1 swrsub=-1 mismatch=1 m=1
    N14 (net028 net04 inh_gnd inh_gnds) lvtnfet w=200n l=30.00n nf=(1)*(1) ngcon=1 nsig_delvto_uo1=0 nsig_delvto_uo2=0 soa=1 swshe=0 swacc=-1 swrg=-1 swrsub=-1 mismatch=1 m=1
    N13 (sum net08 net047 inh_gnds) lvtnfet w=200n l=30.00n nf=(1)*(1) ngcon=1 nsig_delvto_uo1=0 nsig_delvto_uo2=0 soa=1 swshe=0 swacc=-1 swrg=-1 swrsub=-1 mismatch=1 m=1
    N12 (sum Cout net028 inh_gnds) lvtnfet w=200n l=30.00n nf=(1)*(1) ngcon=1 nsig_delvto_uo1=0 nsig_delvto_uo2=0 soa=1 swshe=0 swacc=-1 swrg=-1 swrsub=-1 mismatch=1 m=1
    N11 (Cout net012 inh_gnd inh_gnds) lvtnfet w=200n l=30.00n nf=(1)*(1) ngcon=1 nsig_delvto_uo1=0 nsig_delvto_uo2=0 soa=1 swshe=0 swacc=0 swrg=0 swrsub=0 mismatch=1 m=1
    N10 (net051 A inh_gnd inh_gnds) lvtnfet w=200n l=30.00n nf=(1)*(1) ngcon=1 nsig_delvto_uo1=0 nsig_delvto_uo2=0 soa=1 swshe=0 swacc=-1 swrg=-1 swrsub=-1 mismatch=1 m=1
    N9 (net011 B inh_gnd inh_gnds) lvtnfet w=200n l=30.00n nf=(1)*(1) ngcon=1 nsig_delvto_uo1=0 nsig_delvto_uo2=0 soa=1 swshe=0 swacc=-1 swrg=-1 swrsub=-1 mismatch=1 m=1
    N8 (net011 A inh_gnd inh_gnds) lvtnfet w=200n l=30.00n nf=(1)*(1) ngcon=1 nsig_delvto_uo1=0 nsig_delvto_uo2=0 soa=1 swshe=0 swacc=-1 swrg=-1 swrsub=-1 mismatch=1 m=1
    N7 (net012 B net051 inh_gnds) lvtnfet w=200n l=30.00n nf=(1)*(1) ngcon=1 nsig_delvto_uo1=0 nsig_delvto_uo2=0 soa=1 swshe=0 swacc=-1 swrg=-1 swrsub=-1 mismatch=1 m=1
    N6 (net012 Cin net011 inh_gnds) lvtnfet w=200n l=30.00n nf=(1)*(1) ngcon=1 nsig_delvto_uo1=0 nsig_delvto_uo2=0 soa=1 swshe=0 swacc=-1 swrg=-1 swrsub=-1 mismatch=1 m=1
    N4 (net08 B net016 inh_gnds) lvtnfet w=200n l=30.00n nf=(1)*(1) ngcon=1 nsig_delvto_uo1=0 nsig_delvto_uo2=0 soa=1 swshe=0 swacc=-1 swrg=-1 swrsub=-1 mismatch=1 m=1
    N2 (net08 Cin net07 inh_gnds) lvtnfet w=200n l=30.00n nf=(1)*(1) ngcon=1 nsig_delvto_uo1=0 nsig_delvto_uo2=0 soa=1 swshe=0 swacc=-1 swrg=-1 swrsub=-1 mismatch=1 m=1
    N3 (net016 net04 inh_gnd inh_gnds) lvtnfet w=200n l=30.00n nf=(1)*(1) ngcon=1 nsig_delvto_uo1=0 nsig_delvto_uo2=0 soa=1 swshe=0 swacc=-1 swrg=-1 swrsub=-1 mismatch=1 m=1
    N1 (net07 B inh_gnd inh_gnds) lvtnfet w=200n l=30.00n nf=(1)*(1) ngcon=1 nsig_delvto_uo1=0 nsig_delvto_uo2=0 soa=1 swshe=0 swacc=-1 swrg=-1 swrsub=-1 mismatch=1 m=1
    N0 (net07 net04 inh_gnd inh_gnds) lvtnfet w=200n l=30.00n nf=(1)*(1) ngcon=1 nsig_delvto_uo1=0 nsig_delvto_uo2=0 soa=1 swshe=0 swacc=-1 swrg=-1 swrsub=-1 mismatch=1 m=1
    N5 (net04 A inh_gnd inh_gnds) lvtnfet w=400n l=30.00n nf=(2)*(1) ngcon=1 nsig_delvto_uo1=0 nsig_delvto_uo2=0 soa=1 swshe=0 swacc=0 swrg=0 swrsub=0 mismatch=1 m=1
    P16 (net030 net04 inh_vdd inh_vdds) lvtpfet w=275n l=30.00n nf=(1)*(1) ngcon=1 nsig_delvto_uo1=0 nsig_delvto_uo2=0 soa=1 swshe=0 swacc=-1 swrg=-1 swrsub=-1 mismatch=1 m=1
    P15 (net030 net08 inh_vdd inh_vdds) lvtpfet w=275n l=30.00n nf=(1)*(1) ngcon=1 nsig_delvto_uo1=0 nsig_delvto_uo2=0 soa=1 swshe=0 swacc=-1 swrg=-1 swrsub=-1 mismatch=1 m=1
    P14 (net048 net04 inh_vdd inh_vdds) lvtpfet w=275n l=30.00n nf=(1)*(1) ngcon=1 nsig_delvto_uo1=0 nsig_delvto_uo2=0 soa=1 swshe=0 swacc=-1 swrg=-1 swrsub=-1 mismatch=1 m=1
    P13 (sum net08 net048 inh_vdds) lvtpfet w=275n l=30.00n nf=(1)*(1) ngcon=1 nsig_delvto_uo1=0 nsig_delvto_uo2=0 soa=1 swshe=0 swacc=-1 swrg=-1 swrsub=-1 mismatch=1 m=1
    P12 (sum Cout net030 inh_vdds) lvtpfet w=275n l=30.00n nf=(1)*(1) ngcon=1 nsig_delvto_uo1=0 nsig_delvto_uo2=0 soa=1 swshe=0 swacc=-1 swrg=-1 swrsub=-1 mismatch=1 m=1
    P11 (Cout net012 inh_vdd inh_vdds) lvtpfet w=275n l=30.00n nf=(1)*(1) ngcon=1 nsig_delvto_uo1=0 nsig_delvto_uo2=0 soa=1 swshe=0 swacc=0 swrg=0 swrsub=0 mismatch=1 m=1
    P10 (net052 A inh_vdd inh_vdds) lvtpfet w=275n l=30.00n nf=(1)*(1) ngcon=1 nsig_delvto_uo1=0 nsig_delvto_uo2=0 soa=1 swshe=0 swacc=-1 swrg=-1 swrsub=-1 mismatch=1 m=1
    P9 (net013 B inh_vdd inh_vdds) lvtpfet w=275n l=30.00n nf=(1)*(1) ngcon=1 nsig_delvto_uo1=0 nsig_delvto_uo2=0 soa=1 swshe=0 swacc=-1 swrg=-1 swrsub=-1 mismatch=1 m=1
    P8 (net013 A inh_vdd inh_vdds) lvtpfet w=275n l=30.00n nf=(1)*(1) ngcon=1 nsig_delvto_uo1=0 nsig_delvto_uo2=0 soa=1 swshe=0 swacc=-1 swrg=-1 swrsub=-1 mismatch=1 m=1
    P7 (net012 B net052 inh_vdds) lvtpfet w=275n l=30.00n nf=(1)*(1) ngcon=1 nsig_delvto_uo1=0 nsig_delvto_uo2=0 soa=1 swshe=0 swacc=-1 swrg=-1 swrsub=-1 mismatch=1 m=1
    P6 (net012 Cin net013 inh_vdds) lvtpfet w=275n l=30.00n nf=(1)*(1) ngcon=1 nsig_delvto_uo1=0 nsig_delvto_uo2=0 soa=1 swshe=0 swacc=-1 swrg=-1 swrsub=-1 mismatch=1 m=1
    P3 (net017 net04 inh_vdd inh_vdds) lvtpfet w=275n l=30.00n nf=(1)*(1) ngcon=1 nsig_delvto_uo1=0 nsig_delvto_uo2=0 soa=1 swshe=0 swacc=-1 swrg=-1 swrsub=-1 mismatch=1 m=1
    P1 (net09 B inh_vdd inh_vdds) lvtpfet w=275n l=30.00n nf=(1)*(1) ngcon=1 nsig_delvto_uo1=0 nsig_delvto_uo2=0 soa=1 swshe=0 swacc=-1 swrg=-1 swrsub=-1 mismatch=1 m=1
    P0 (net09 net04 inh_vdd inh_vdds) lvtpfet w=275n l=30.00n nf=(1)*(1) ngcon=1 nsig_delvto_uo1=0 nsig_delvto_uo2=0 soa=1 swshe=0 swacc=-1 swrg=-1 swrsub=-1 mismatch=1 m=1
    P4 (net08 B net017 inh_vdds) lvtpfet w=275n l=30.00n nf=(1)*(1) ngcon=1 nsig_delvto_uo1=0 nsig_delvto_uo2=0 soa=1 swshe=0 swacc=-1 swrg=-1 swrsub=-1 mismatch=1 m=1
    P2 (net08 Cin net09 inh_vdds) lvtpfet w=275n l=30.00n nf=(1)*(1) ngcon=1 nsig_delvto_uo1=0 nsig_delvto_uo2=0 soa=1 swshe=0 swacc=-1 swrg=-1 swrsub=-1 mismatch=1 m=1
    P5 (net04 A inh_vdd inh_vdds) lvtpfet w=550n l=30.00n nf=(2)*(1) ngcon=1 nsig_delvto_uo1=0 nsig_delvto_uo2=0 soa=1 swshe=0 swacc=0 swrg=0 swrsub=0 mismatch=1 m=1
ends LVT_FAx1_PB4_AFBB

// power_gating_fine/alu_adder_DW01_add_0/schematic
subckt alu_adder_DW01_add_0 A\<31\> A\<30\> A\<29\> A\<28\> A\<27\> A\<26\> A\<25\> A\<24\> A\<23\> A\<22\> A\<21\> A\<20\> A\<19\> A\<18\> A\<17\> A\<16\> A\<15\> A\<14\> A\<13\> A\<12\> A\<11\> A\<10\> A\<9\> A\<8\> A\<7\> A\<6\> A\<5\> A\<4\> A\<3\> A\<2\> A\<1\> A\<0\> B\<31\> B\<30\> B\<29\> B\<28\> B\<27\> B\<26\> B\<25\> B\<24\> B\<23\> B\<22\> B\<21\> B\<20\> B\<19\> B\<18\> B\<17\> B\<16\> B\<15\> B\<14\> B\<13\> B\<12\> B\<11\> B\<10\> B\<9\> B\<8\> B\<7\> B\<6\> B\<5\> B\<4\> B\<3\> B\<2\> B\<1\> B\<0\> CI SUM\<31\> SUM\<30\> SUM\<29\> SUM\<28\> SUM\<27\> SUM\<26\> SUM\<25\> SUM\<24\> SUM\<23\> SUM\<22\> SUM\<21\> SUM\<20\> SUM\<19\> SUM\<18\> SUM\<17\> SUM\<16\> SUM\<15\> SUM\<14\> SUM\<13\> SUM\<12\> SUM\<11\> SUM\<10\> SUM\<9\> SUM\<8\> SUM\<7\> SUM\<6\> SUM\<5\> SUM\<4\> SUM\<3\> SUM\<2\> SUM\<1\> SUM\<0\> CO inh_gnd inh_gnds inh_vdd inh_vdds
    U385 (n366 n358 inh_gnd inh_gnds inh_vdd inh_vdds) LVT_invx2_PB4_AFBB
    U390 (n368 n362 inh_gnd inh_gnds inh_vdd inh_vdds) LVT_invx2_PB4_AFBB
    U147 (B\<30\> n141 inh_gnd inh_gnds inh_vdd inh_vdds) LVT_invx2_PB4_AFBB
    U366 (n346 SUM\<30\> inh_gnd inh_gnds inh_vdd inh_vdds) LVT_invx2_PB4_AFBB
    U388 (n367 n361 inh_gnd inh_gnds inh_vdd inh_vdds) LVT_invx2_PB4_AFBB
    U133 (A\<30\> n127 inh_gnd inh_gnds inh_vdd inh_vdds) LVT_invx2_PB4_AFBB
    U383 (n365 n356 inh_gnd inh_gnds inh_vdd inh_vdds) LVT_invx2_PB4_AFBB
    U148 (B\<30\> n142 inh_gnd inh_gnds inh_vdd inh_vdds) LVT_invx2_PB4_AFBB
    U381 (n364 n354 inh_gnd inh_gnds inh_vdd inh_vdds) LVT_invx2_PB4_AFBB
    U143 (n360 n137 inh_gnd inh_gnds inh_vdd inh_vdds) LVT_invx2_PB4_AFBB
    U149 (B\<30\> n143 inh_gnd inh_gnds inh_vdd inh_vdds) LVT_invx2_PB4_AFBB
    U379 (n363 n352 inh_gnd inh_gnds inh_vdd inh_vdds) LVT_invx2_PB4_AFBB
    U365 (n345 carry\<31\> inh_gnd inh_gnds inh_vdd inh_vdds) LVT_invx2_PB4_AFBB
    U368 (B\<30\> n348 inh_gnd inh_gnds inh_vdd inh_vdds) LVT_invx2_PB4_AFBB
    U367 (A\<30\> n347 inh_gnd inh_gnds inh_vdd inh_vdds) LVT_invx2_PB4_AFBB
    U359 (n342 n334 inh_gnd inh_gnds inh_vdd inh_vdds) LVT_invx2_PB4_AFBB
    U364 (n344 n338 inh_gnd inh_gnds inh_vdd inh_vdds) LVT_invx2_PB4_AFBB
    U150 (B\<27\> n144 inh_gnd inh_gnds inh_vdd inh_vdds) LVT_invx2_PB4_AFBB
    U340 (n322 SUM\<27\> inh_gnd inh_gnds inh_vdd inh_vdds) LVT_invx2_PB4_AFBB
    U362 (n343 n337 inh_gnd inh_gnds inh_vdd inh_vdds) LVT_invx2_PB4_AFBB
    U122 (A\<27\> n116 inh_gnd inh_gnds inh_vdd inh_vdds) LVT_invx2_PB4_AFBB
    U357 (n341 n332 inh_gnd inh_gnds inh_vdd inh_vdds) LVT_invx2_PB4_AFBB
    U151 (B\<27\> n145 inh_gnd inh_gnds inh_vdd inh_vdds) LVT_invx2_PB4_AFBB
    U355 (n340 n330 inh_gnd inh_gnds inh_vdd inh_vdds) LVT_invx2_PB4_AFBB
    U138 (n336 n132 inh_gnd inh_gnds inh_vdd inh_vdds) LVT_invx2_PB4_AFBB
    U152 (B\<27\> n146 inh_gnd inh_gnds inh_vdd inh_vdds) LVT_invx2_PB4_AFBB
    U353 (n339 n328 inh_gnd inh_gnds inh_vdd inh_vdds) LVT_invx2_PB4_AFBB
    U339 (n321 carry\<28\> inh_gnd inh_gnds inh_vdd inh_vdds) LVT_invx2_PB4_AFBB
    U342 (B\<27\> n324 inh_gnd inh_gnds inh_vdd inh_vdds) LVT_invx2_PB4_AFBB
    U341 (A\<27\> n323 inh_gnd inh_gnds inh_vdd inh_vdds) LVT_invx2_PB4_AFBB
    U333 (n318 n310 inh_gnd inh_gnds inh_vdd inh_vdds) LVT_invx2_PB4_AFBB
    U338 (n320 n314 inh_gnd inh_gnds inh_vdd inh_vdds) LVT_invx2_PB4_AFBB
    U153 (B\<24\> n147 inh_gnd inh_gnds inh_vdd inh_vdds) LVT_invx2_PB4_AFBB
    U314 (n298 SUM\<24\> inh_gnd inh_gnds inh_vdd inh_vdds) LVT_invx2_PB4_AFBB
    U336 (n319 n313 inh_gnd inh_gnds inh_vdd inh_vdds) LVT_invx2_PB4_AFBB
    U124 (A\<24\> n118 inh_gnd inh_gnds inh_vdd inh_vdds) LVT_invx2_PB4_AFBB
    U331 (n317 n308 inh_gnd inh_gnds inh_vdd inh_vdds) LVT_invx2_PB4_AFBB
    U154 (B\<24\> n148 inh_gnd inh_gnds inh_vdd inh_vdds) LVT_invx2_PB4_AFBB
    U329 (n316 n306 inh_gnd inh_gnds inh_vdd inh_vdds) LVT_invx2_PB4_AFBB
    U137 (n312 n131 inh_gnd inh_gnds inh_vdd inh_vdds) LVT_invx2_PB4_AFBB
    U155 (B\<24\> n149 inh_gnd inh_gnds inh_vdd inh_vdds) LVT_invx2_PB4_AFBB
    U327 (n315 n304 inh_gnd inh_gnds inh_vdd inh_vdds) LVT_invx2_PB4_AFBB
    U313 (n297 carry\<25\> inh_gnd inh_gnds inh_vdd inh_vdds) LVT_invx2_PB4_AFBB
    U316 (B\<24\> n300 inh_gnd inh_gnds inh_vdd inh_vdds) LVT_invx2_PB4_AFBB
    U315 (A\<24\> n299 inh_gnd inh_gnds inh_vdd inh_vdds) LVT_invx2_PB4_AFBB
    U307 (n294 n286 inh_gnd inh_gnds inh_vdd inh_vdds) LVT_invx2_PB4_AFBB
    U312 (n296 n290 inh_gnd inh_gnds inh_vdd inh_vdds) LVT_invx2_PB4_AFBB
    U156 (B\<21\> n150 inh_gnd inh_gnds inh_vdd inh_vdds) LVT_invx2_PB4_AFBB
    U288 (n274 SUM\<21\> inh_gnd inh_gnds inh_vdd inh_vdds) LVT_invx2_PB4_AFBB
    U310 (n295 n289 inh_gnd inh_gnds inh_vdd inh_vdds) LVT_invx2_PB4_AFBB
    U126 (A\<21\> n120 inh_gnd inh_gnds inh_vdd inh_vdds) LVT_invx2_PB4_AFBB
    U305 (n293 n284 inh_gnd inh_gnds inh_vdd inh_vdds) LVT_invx2_PB4_AFBB
    U157 (B\<21\> n151 inh_gnd inh_gnds inh_vdd inh_vdds) LVT_invx2_PB4_AFBB
    U303 (n292 n282 inh_gnd inh_gnds inh_vdd inh_vdds) LVT_invx2_PB4_AFBB
    U136 (n288 n130 inh_gnd inh_gnds inh_vdd inh_vdds) LVT_invx2_PB4_AFBB
    U158 (B\<21\> n152 inh_gnd inh_gnds inh_vdd inh_vdds) LVT_invx2_PB4_AFBB
    U301 (n291 n280 inh_gnd inh_gnds inh_vdd inh_vdds) LVT_invx2_PB4_AFBB
    U2 (n1 n2 inh_gnd inh_gnds inh_vdd inh_vdds) LVT_invx2_PB4_AFBB
    U1 (carry\<1\> n1 inh_gnd inh_gnds inh_vdd inh_vdds) LVT_invx2_PB4_AFBB
    U393 (B\<0\> n370 inh_gnd inh_gnds inh_vdd inh_vdds) LVT_invx2_PB4_AFBB
    U207 (A\<0\> n199 inh_gnd inh_gnds inh_vdd inh_vdds) LVT_invx2_PB4_AFBB
    U392 (A\<0\> n369 inh_gnd inh_gnds inh_vdd inh_vdds) LVT_invx2_PB4_AFBB
    U398 (n374 n371 inh_gnd inh_gnds inh_vdd inh_vdds) LVT_invx2_PB4_AFBB
    U397 (n373 n372 inh_gnd inh_gnds inh_vdd inh_vdds) LVT_invx2_PB4_AFBB
    U195 (B\<0\> n187 inh_gnd inh_gnds inh_vdd inh_vdds) LVT_invx2_PB4_AFBB
    U386 (n349 n360 inh_gnd inh_gnds inh_vdd inh_vdds) LVT_invx2_PB4_AFBB
    U132 (A\<30\> n126 inh_gnd inh_gnds inh_vdd inh_vdds) LVT_invx2_PB4_AFBB
    U360 (n325 n336 inh_gnd inh_gnds inh_vdd inh_vdds) LVT_invx2_PB4_AFBB
    U121 (A\<27\> n115 inh_gnd inh_gnds inh_vdd inh_vdds) LVT_invx2_PB4_AFBB
    U334 (n301 n312 inh_gnd inh_gnds inh_vdd inh_vdds) LVT_invx2_PB4_AFBB
    U123 (A\<24\> n117 inh_gnd inh_gnds inh_vdd inh_vdds) LVT_invx2_PB4_AFBB
    U308 (n277 n288 inh_gnd inh_gnds inh_vdd inh_vdds) LVT_invx2_PB4_AFBB
    U125 (A\<21\> n119 inh_gnd inh_gnds inh_vdd inh_vdds) LVT_invx2_PB4_AFBB
    U196 (n23 n188 inh_gnd inh_gnds inh_vdd inh_vdds) LVT_invx2_PB4_AFBB
    U23 (carry\<30\> n23 inh_gnd inh_gnds inh_vdd inh_vdds) LVT_invx2_PB4_AFBB
    U198 (n189 n190 inh_gnd inh_gnds inh_vdd inh_vdds) LVT_invx2_PB4_AFBB
    U197 (carry\<27\> n189 inh_gnd inh_gnds inh_vdd inh_vdds) LVT_invx2_PB4_AFBB
    U200 (n191 n192 inh_gnd inh_gnds inh_vdd inh_vdds) LVT_invx2_PB4_AFBB
    U199 (carry\<24\> n191 inh_gnd inh_gnds inh_vdd inh_vdds) LVT_invx2_PB4_AFBB
    U202 (n193 n194 inh_gnd inh_gnds inh_vdd inh_vdds) LVT_invx2_PB4_AFBB
    U201 (carry\<21\> n193 inh_gnd inh_gnds inh_vdd inh_vdds) LVT_invx2_PB4_AFBB
    U290 (B\<21\> n276 inh_gnd inh_gnds inh_vdd inh_vdds) LVT_invx2_PB4_AFBB
    U289 (A\<21\> n275 inh_gnd inh_gnds inh_vdd inh_vdds) LVT_invx2_PB4_AFBB
    U287 (n273 carry\<22\> inh_gnd inh_gnds inh_vdd inh_vdds) LVT_invx2_PB4_AFBB
    U281 (n270 n262 inh_gnd inh_gnds inh_vdd inh_vdds) LVT_invx2_PB4_AFBB
    U286 (n272 n266 inh_gnd inh_gnds inh_vdd inh_vdds) LVT_invx2_PB4_AFBB
    U159 (B\<18\> n153 inh_gnd inh_gnds inh_vdd inh_vdds) LVT_invx2_PB4_AFBB
    U262 (n250 SUM\<18\> inh_gnd inh_gnds inh_vdd inh_vdds) LVT_invx2_PB4_AFBB
    U284 (n271 n265 inh_gnd inh_gnds inh_vdd inh_vdds) LVT_invx2_PB4_AFBB
    U128 (A\<18\> n122 inh_gnd inh_gnds inh_vdd inh_vdds) LVT_invx2_PB4_AFBB
    U279 (n269 n260 inh_gnd inh_gnds inh_vdd inh_vdds) LVT_invx2_PB4_AFBB
    U160 (B\<18\> n154 inh_gnd inh_gnds inh_vdd inh_vdds) LVT_invx2_PB4_AFBB
    U277 (n268 n258 inh_gnd inh_gnds inh_vdd inh_vdds) LVT_invx2_PB4_AFBB
    U135 (n264 n129 inh_gnd inh_gnds inh_vdd inh_vdds) LVT_invx2_PB4_AFBB
    U161 (B\<18\> n155 inh_gnd inh_gnds inh_vdd inh_vdds) LVT_invx2_PB4_AFBB
    U275 (n267 n256 inh_gnd inh_gnds inh_vdd inh_vdds) LVT_invx2_PB4_AFBB
    U261 (n249 carry\<19\> inh_gnd inh_gnds inh_vdd inh_vdds) LVT_invx2_PB4_AFBB
    U264 (B\<18\> n252 inh_gnd inh_gnds inh_vdd inh_vdds) LVT_invx2_PB4_AFBB
    U263 (A\<18\> n251 inh_gnd inh_gnds inh_vdd inh_vdds) LVT_invx2_PB4_AFBB
    U255 (n246 n238 inh_gnd inh_gnds inh_vdd inh_vdds) LVT_invx2_PB4_AFBB
    U260 (n248 n242 inh_gnd inh_gnds inh_vdd inh_vdds) LVT_invx2_PB4_AFBB
    U162 (B\<15\> n156 inh_gnd inh_gnds inh_vdd inh_vdds) LVT_invx2_PB4_AFBB
    U236 (n226 SUM\<15\> inh_gnd inh_gnds inh_vdd inh_vdds) LVT_invx2_PB4_AFBB
    U258 (n247 n241 inh_gnd inh_gnds inh_vdd inh_vdds) LVT_invx2_PB4_AFBB
    U130 (A\<15\> n124 inh_gnd inh_gnds inh_vdd inh_vdds) LVT_invx2_PB4_AFBB
    U253 (n245 n236 inh_gnd inh_gnds inh_vdd inh_vdds) LVT_invx2_PB4_AFBB
    U163 (B\<15\> n157 inh_gnd inh_gnds inh_vdd inh_vdds) LVT_invx2_PB4_AFBB
    U251 (n244 n234 inh_gnd inh_gnds inh_vdd inh_vdds) LVT_invx2_PB4_AFBB
    U134 (n240 n128 inh_gnd inh_gnds inh_vdd inh_vdds) LVT_invx2_PB4_AFBB
    U164 (B\<15\> n158 inh_gnd inh_gnds inh_vdd inh_vdds) LVT_invx2_PB4_AFBB
    U249 (n243 n232 inh_gnd inh_gnds inh_vdd inh_vdds) LVT_invx2_PB4_AFBB
    U235 (n225 carry\<16\> inh_gnd inh_gnds inh_vdd inh_vdds) LVT_invx2_PB4_AFBB
    U238 (B\<15\> n228 inh_gnd inh_gnds inh_vdd inh_vdds) LVT_invx2_PB4_AFBB
    U237 (A\<15\> n227 inh_gnd inh_gnds inh_vdd inh_vdds) LVT_invx2_PB4_AFBB
    U228 (n221 n213 inh_gnd inh_gnds inh_vdd inh_vdds) LVT_invx2_PB4_AFBB
    U234 (n224 n217 inh_gnd inh_gnds inh_vdd inh_vdds) LVT_invx2_PB4_AFBB
    U146 (B\<12\> n140 inh_gnd inh_gnds inh_vdd inh_vdds) LVT_invx2_PB4_AFBB
    U209 (n201 SUM\<12\> inh_gnd inh_gnds inh_vdd inh_vdds) LVT_invx2_PB4_AFBB
    U232 (n223 n216 inh_gnd inh_gnds inh_vdd inh_vdds) LVT_invx2_PB4_AFBB
    U211 (A\<12\> n203 inh_gnd inh_gnds inh_vdd inh_vdds) LVT_invx2_PB4_AFBB
    U226 (n220 n211 inh_gnd inh_gnds inh_vdd inh_vdds) LVT_invx2_PB4_AFBB
    U144 (B\<12\> n138 inh_gnd inh_gnds inh_vdd inh_vdds) LVT_invx2_PB4_AFBB
    U224 (n219 n209 inh_gnd inh_gnds inh_vdd inh_vdds) LVT_invx2_PB4_AFBB
    U131 (n215 n125 inh_gnd inh_gnds inh_vdd inh_vdds) LVT_invx2_PB4_AFBB
    U212 (B\<12\> n204 inh_gnd inh_gnds inh_vdd inh_vdds) LVT_invx2_PB4_AFBB
    U222 (n218 n207 inh_gnd inh_gnds inh_vdd inh_vdds) LVT_invx2_PB4_AFBB
    U208 (n200 carry\<13\> inh_gnd inh_gnds inh_vdd inh_vdds) LVT_invx2_PB4_AFBB
    U167 (A\<12\> n161 inh_gnd inh_gnds inh_vdd inh_vdds) LVT_invx2_PB4_AFBB
    U145 (B\<12\> n139 inh_gnd inh_gnds inh_vdd inh_vdds) LVT_invx2_PB4_AFBB
    U189 (n184 n176 inh_gnd inh_gnds inh_vdd inh_vdds) LVT_invx2_PB4_AFBB
    U194 (n186 n180 inh_gnd inh_gnds inh_vdd inh_vdds) LVT_invx2_PB4_AFBB
    U140 (B\<11\> n134 inh_gnd inh_gnds inh_vdd inh_vdds) LVT_invx2_PB4_AFBB
    U170 (n164 SUM\<11\> inh_gnd inh_gnds inh_vdd inh_vdds) LVT_invx2_PB4_AFBB
    U192 (n185 n179 inh_gnd inh_gnds inh_vdd inh_vdds) LVT_invx2_PB4_AFBB
    U120 (A\<11\> n114 inh_gnd inh_gnds inh_vdd inh_vdds) LVT_invx2_PB4_AFBB
    U187 (n183 n174 inh_gnd inh_gnds inh_vdd inh_vdds) LVT_invx2_PB4_AFBB
    U141 (B\<11\> n135 inh_gnd inh_gnds inh_vdd inh_vdds) LVT_invx2_PB4_AFBB
    U185 (n182 n172 inh_gnd inh_gnds inh_vdd inh_vdds) LVT_invx2_PB4_AFBB
    U139 (n178 n133 inh_gnd inh_gnds inh_vdd inh_vdds) LVT_invx2_PB4_AFBB
    U142 (B\<11\> n136 inh_gnd inh_gnds inh_vdd inh_vdds) LVT_invx2_PB4_AFBB
    U183 (n181 n170 inh_gnd inh_gnds inh_vdd inh_vdds) LVT_invx2_PB4_AFBB
    U169 (n163 carry\<12\> inh_gnd inh_gnds inh_vdd inh_vdds) LVT_invx2_PB4_AFBB
    U172 (B\<11\> n166 inh_gnd inh_gnds inh_vdd inh_vdds) LVT_invx2_PB4_AFBB
    U171 (A\<11\> n165 inh_gnd inh_gnds inh_vdd inh_vdds) LVT_invx2_PB4_AFBB
    U282 (n253 n264 inh_gnd inh_gnds inh_vdd inh_vdds) LVT_invx2_PB4_AFBB
    U127 (A\<18\> n121 inh_gnd inh_gnds inh_vdd inh_vdds) LVT_invx2_PB4_AFBB
    U256 (n229 n240 inh_gnd inh_gnds inh_vdd inh_vdds) LVT_invx2_PB4_AFBB
    U129 (A\<15\> n123 inh_gnd inh_gnds inh_vdd inh_vdds) LVT_invx2_PB4_AFBB
    U230 (n222 n215 inh_gnd inh_gnds inh_vdd inh_vdds) LVT_invx2_PB4_AFBB
    U168 (A\<12\> n162 inh_gnd inh_gnds inh_vdd inh_vdds) LVT_invx2_PB4_AFBB
    U190 (n167 n178 inh_gnd inh_gnds inh_vdd inh_vdds) LVT_invx2_PB4_AFBB
    U119 (A\<11\> n113 inh_gnd inh_gnds inh_vdd inh_vdds) LVT_invx2_PB4_AFBB
    U113 (n110 n102 inh_gnd inh_gnds inh_vdd inh_vdds) LVT_invx2_PB4_AFBB
    U204 (n195 n196 inh_gnd inh_gnds inh_vdd inh_vdds) LVT_invx2_PB4_AFBB
    U203 (carry\<18\> n195 inh_gnd inh_gnds inh_vdd inh_vdds) LVT_invx2_PB4_AFBB
    U206 (n197 n198 inh_gnd inh_gnds inh_vdd inh_vdds) LVT_invx2_PB4_AFBB
    U205 (carry\<15\> n197 inh_gnd inh_gnds inh_vdd inh_vdds) LVT_invx2_PB4_AFBB
    U210 (carry\<12\> n202 inh_gnd inh_gnds inh_vdd inh_vdds) LVT_invx2_PB4_AFBB
    U166 (n159 n160 inh_gnd inh_gnds inh_vdd inh_vdds) LVT_invx2_PB4_AFBB
    U165 (carry\<11\> n159 inh_gnd inh_gnds inh_vdd inh_vdds) LVT_invx2_PB4_AFBB
    U96 (A\<9\> n92 inh_gnd inh_gnds inh_vdd inh_vdds) LVT_invx2_PB4_AFBB
    U111 (n109 n100 inh_gnd inh_gnds inh_vdd inh_vdds) LVT_invx2_PB4_AFBB
    U116 (n111 n105 inh_gnd inh_gnds inh_vdd inh_vdds) LVT_invx2_PB4_AFBB
    U94 (n90 SUM\<9\> inh_gnd inh_gnds inh_vdd inh_vdds) LVT_invx2_PB4_AFBB
    U118 (n112 n106 inh_gnd inh_gnds inh_vdd inh_vdds) LVT_invx2_PB4_AFBB
    U95 (n87 n91 inh_gnd inh_gnds inh_vdd inh_vdds) LVT_invx2_PB4_AFBB
    U29 (B\<9\> n29 inh_gnd inh_gnds inh_vdd inh_vdds) LVT_invx2_PB4_AFBB
    U15 (B\<9\> n15 inh_gnd inh_gnds inh_vdd inh_vdds) LVT_invx2_PB4_AFBB
    U109 (n108 n98 inh_gnd inh_gnds inh_vdd inh_vdds) LVT_invx2_PB4_AFBB
    U24 (n104 n24 inh_gnd inh_gnds inh_vdd inh_vdds) LVT_invx2_PB4_AFBB
    U30 (B\<9\> n30 inh_gnd inh_gnds inh_vdd inh_vdds) LVT_invx2_PB4_AFBB
    U107 (n107 n96 inh_gnd inh_gnds inh_vdd inh_vdds) LVT_invx2_PB4_AFBB
    U93 (n89 carry\<10\> inh_gnd inh_gnds inh_vdd inh_vdds) LVT_invx2_PB4_AFBB
    U19 (A\<9\> n19 inh_gnd inh_gnds inh_vdd inh_vdds) LVT_invx2_PB4_AFBB
    U16 (B\<9\> n16 inh_gnd inh_gnds inh_vdd inh_vdds) LVT_invx2_PB4_AFBB
    U84 (n83 n75 inh_gnd inh_gnds inh_vdd inh_vdds) LVT_invx2_PB4_AFBB
    U66 (n36 n64 inh_gnd inh_gnds inh_vdd inh_vdds) LVT_invx2_PB4_AFBB
    U89 (n85 n79 inh_gnd inh_gnds inh_vdd inh_vdds) LVT_invx2_PB4_AFBB
    U27 (B\<6\> n27 inh_gnd inh_gnds inh_vdd inh_vdds) LVT_invx2_PB4_AFBB
    U65 (n63 SUM\<6\> inh_gnd inh_gnds inh_vdd inh_vdds) LVT_invx2_PB4_AFBB
    U87 (n84 n78 inh_gnd inh_gnds inh_vdd inh_vdds) LVT_invx2_PB4_AFBB
    U67 (A\<6\> n65 inh_gnd inh_gnds inh_vdd inh_vdds) LVT_invx2_PB4_AFBB
    U82 (n82 n73 inh_gnd inh_gnds inh_vdd inh_vdds) LVT_invx2_PB4_AFBB
    U13 (B\<6\> n13 inh_gnd inh_gnds inh_vdd inh_vdds) LVT_invx2_PB4_AFBB
    U80 (n81 n71 inh_gnd inh_gnds inh_vdd inh_vdds) LVT_invx2_PB4_AFBB
    U26 (n77 n26 inh_gnd inh_gnds inh_vdd inh_vdds) LVT_invx2_PB4_AFBB
    U28 (B\<6\> n28 inh_gnd inh_gnds inh_vdd inh_vdds) LVT_invx2_PB4_AFBB
    U78 (n80 n69 inh_gnd inh_gnds inh_vdd inh_vdds) LVT_invx2_PB4_AFBB
    U64 (n62 carry\<7\> inh_gnd inh_gnds inh_vdd inh_vdds) LVT_invx2_PB4_AFBB
    U17 (A\<6\> n17 inh_gnd inh_gnds inh_vdd inh_vdds) LVT_invx2_PB4_AFBB
    U14 (B\<6\> n14 inh_gnd inh_gnds inh_vdd inh_vdds) LVT_invx2_PB4_AFBB
    U57 (n58 n50 inh_gnd inh_gnds inh_vdd inh_vdds) LVT_invx2_PB4_AFBB
    U63 (n61 n54 inh_gnd inh_gnds inh_vdd inh_vdds) LVT_invx2_PB4_AFBB
    U39 (n39 SUM\<7\> inh_gnd inh_gnds inh_vdd inh_vdds) LVT_invx2_PB4_AFBB
    U53 (n56 n46 inh_gnd inh_gnds inh_vdd inh_vdds) LVT_invx2_PB4_AFBB
    U61 (n60 n53 inh_gnd inh_gnds inh_vdd inh_vdds) LVT_invx2_PB4_AFBB
    U41 (A\<7\> n41 inh_gnd inh_gnds inh_vdd inh_vdds) LVT_invx2_PB4_AFBB
    U55 (n57 n48 inh_gnd inh_gnds inh_vdd inh_vdds) LVT_invx2_PB4_AFBB
    U21 (A\<7\> n21 inh_gnd inh_gnds inh_vdd inh_vdds) LVT_invx2_PB4_AFBB
    U38 (n38 carry\<8\> inh_gnd inh_gnds inh_vdd inh_vdds) LVT_invx2_PB4_AFBB
    U51 (n55 n44 inh_gnd inh_gnds inh_vdd inh_vdds) LVT_invx2_PB4_AFBB
    U25 (n52 n25 inh_gnd inh_gnds inh_vdd inh_vdds) LVT_invx2_PB4_AFBB
    U114 (n93 n104 inh_gnd inh_gnds inh_vdd inh_vdds) LVT_invx2_PB4_AFBB
    U20 (A\<9\> n20 inh_gnd inh_gnds inh_vdd inh_vdds) LVT_invx2_PB4_AFBB
    U85 (n66 n77 inh_gnd inh_gnds inh_vdd inh_vdds) LVT_invx2_PB4_AFBB
    U18 (A\<6\> n18 inh_gnd inh_gnds inh_vdd inh_vdds) LVT_invx2_PB4_AFBB
    U59 (n59 n52 inh_gnd inh_gnds inh_vdd inh_vdds) LVT_invx2_PB4_AFBB
    U22 (A\<7\> n22 inh_gnd inh_gnds inh_vdd inh_vdds) LVT_invx2_PB4_AFBB
    U92 (n86 n88 inh_gnd inh_gnds inh_vdd inh_vdds) LVT_invx2_PB4_AFBB
    U91 (n86 n87 inh_gnd inh_gnds inh_vdd inh_vdds) LVT_invx2_PB4_AFBB
    U90 (carry\<9\> n86 inh_gnd inh_gnds inh_vdd inh_vdds) LVT_invx2_PB4_AFBB
    U33 (n87 n33 inh_gnd inh_gnds inh_vdd inh_vdds) LVT_invx2_PB4_AFBB
    U37 (n35 n37 inh_gnd inh_gnds inh_vdd inh_vdds) LVT_invx2_PB4_AFBB
    U36 (n35 n36 inh_gnd inh_gnds inh_vdd inh_vdds) LVT_invx2_PB4_AFBB
    U35 (carry\<6\> n35 inh_gnd inh_gnds inh_vdd inh_vdds) LVT_invx2_PB4_AFBB
    U34 (n36 n34 inh_gnd inh_gnds inh_vdd inh_vdds) LVT_invx2_PB4_AFBB
    U40 (carry\<7\> n40 inh_gnd inh_gnds inh_vdd inh_vdds) LVT_invx2_PB4_AFBB
    U32 (B\<7\> n32 inh_gnd inh_gnds inh_vdd inh_vdds) LVT_invx2_PB4_AFBB
    U31 (B\<7\> n31 inh_gnd inh_gnds inh_vdd inh_vdds) LVT_invx2_PB4_AFBB
    U8 (carry\<2\> n8 inh_gnd inh_gnds inh_vdd inh_vdds) LVT_BUFx1_PB4_AFBB
    U12 (carry\<3\> n12 inh_gnd inh_gnds inh_vdd inh_vdds) LVT_BUFx1_PB4_AFBB
    U11 (carry\<5\> n11 inh_gnd inh_gnds inh_vdd inh_vdds) LVT_BUFx1_PB4_AFBB
    U10 (carry\<4\> n10 inh_gnd inh_gnds inh_vdd inh_vdds) LVT_BUFx1_PB4_AFBB
    U9 (carry\<29\> n9 inh_gnd inh_gnds inh_vdd inh_vdds) LVT_BUFx1_PB4_AFBB
    U7 (carry\<23\> n7 inh_gnd inh_gnds inh_vdd inh_vdds) LVT_BUFx1_PB4_AFBB
    U6 (carry\<20\> n6 inh_gnd inh_gnds inh_vdd inh_vdds) LVT_BUFx1_PB4_AFBB
    U5 (carry\<14\> n5 inh_gnd inh_gnds inh_vdd inh_vdds) LVT_BUFx1_PB4_AFBB
    U4 (carry\<26\> n4 inh_gnd inh_gnds inh_vdd inh_vdds) LVT_BUFx1_PB4_AFBB
    U3 (carry\<17\> n3 inh_gnd inh_gnds inh_vdd inh_vdds) LVT_BUFx1_PB4_AFBB
    U1_1 (A\<1\> B\<1\> n2 carry\<2\> SUM\<1\> inh_gnd inh_gnds inh_vdd inh_vdds) LVT_FAx1_PB4_AFBB
    U1_8 (A\<8\> B\<8\> carry\<8\> carry\<9\> SUM\<8\> inh_gnd inh_gnds inh_vdd inh_vdds) LVT_FAx1_PB4_AFBB
    U1_10 (A\<10\> B\<10\> carry\<10\> carry\<11\> SUM\<10\> inh_gnd inh_gnds inh_vdd inh_vdds) LVT_FAx1_PB4_AFBB
    U1_13 (A\<13\> B\<13\> carry\<13\> carry\<14\> SUM\<13\> inh_gnd inh_gnds inh_vdd inh_vdds) LVT_FAx1_PB4_AFBB
    U1_16 (A\<16\> B\<16\> carry\<16\> carry\<17\> SUM\<16\> inh_gnd inh_gnds inh_vdd inh_vdds) LVT_FAx1_PB4_AFBB
    U1_19 (A\<19\> B\<19\> carry\<19\> carry\<20\> SUM\<19\> inh_gnd inh_gnds inh_vdd inh_vdds) LVT_FAx1_PB4_AFBB
    U1_22 (A\<22\> B\<22\> carry\<22\> carry\<23\> SUM\<22\> inh_gnd inh_gnds inh_vdd inh_vdds) LVT_FAx1_PB4_AFBB
    U1_25 (A\<25\> B\<25\> carry\<25\> carry\<26\> SUM\<25\> inh_gnd inh_gnds inh_vdd inh_vdds) LVT_FAx1_PB4_AFBB
    U1_28 (A\<28\> B\<28\> carry\<28\> carry\<29\> SUM\<28\> inh_gnd inh_gnds inh_vdd inh_vdds) LVT_FAx1_PB4_AFBB
    U1_31 (A\<31\> B\<31\> carry\<31\> NeTt_1164 SUM\<31\> inh_gnd inh_gnds inh_vdd inh_vdds) LVT_FAx1_PB4_AFBB
    U1_2 (A\<2\> B\<2\> n8 carry\<3\> SUM\<2\> inh_gnd inh_gnds inh_vdd inh_vdds) LVT_FAx1_PB4_AFBB
    U1_3 (A\<3\> B\<3\> n12 carry\<4\> SUM\<3\> inh_gnd inh_gnds inh_vdd inh_vdds) LVT_FAx1_PB4_AFBB
    U1_5 (A\<5\> B\<5\> n11 carry\<6\> SUM\<5\> inh_gnd inh_gnds inh_vdd inh_vdds) LVT_FAx1_PB4_AFBB
    U1_4 (A\<4\> B\<4\> n10 carry\<5\> SUM\<4\> inh_gnd inh_gnds inh_vdd inh_vdds) LVT_FAx1_PB4_AFBB
    U1_29 (A\<29\> B\<29\> n9 carry\<30\> SUM\<29\> inh_gnd inh_gnds inh_vdd inh_vdds) LVT_FAx1_PB4_AFBB
    U1_23 (A\<23\> B\<23\> n7 carry\<24\> SUM\<23\> inh_gnd inh_gnds inh_vdd inh_vdds) LVT_FAx1_PB4_AFBB
    U1_20 (A\<20\> B\<20\> n6 carry\<21\> SUM\<20\> inh_gnd inh_gnds inh_vdd inh_vdds) LVT_FAx1_PB4_AFBB
    U1_14 (A\<14\> B\<14\> n5 carry\<15\> SUM\<14\> inh_gnd inh_gnds inh_vdd inh_vdds) LVT_FAx1_PB4_AFBB
    U1_26 (A\<26\> B\<26\> n4 carry\<27\> SUM\<26\> inh_gnd inh_gnds inh_vdd inh_vdds) LVT_FAx1_PB4_AFBB
    U1_17 (A\<17\> B\<17\> n3 carry\<18\> SUM\<17\> inh_gnd inh_gnds inh_vdd inh_vdds) LVT_FAx1_PB4_AFBB
    U384 (B\<30\> A\<30\> n366 inh_gnd inh_gnds inh_vdd inh_vdds) LVT_NOR2x1_PB4_AFBB
    U375 (n23 n358 n357 inh_gnd inh_gnds inh_vdd inh_vdds) LVT_NOR2x1_PB4_AFBB
    U376 (n360 n141 n359 inh_gnd inh_gnds inh_vdd inh_vdds) LVT_NOR2x1_PB4_AFBB
    U389 (n359 n357 n368 inh_gnd inh_gnds inh_vdd inh_vdds) LVT_NOR2x1_PB4_AFBB
    U387 (n353 n355 n367 inh_gnd inh_gnds inh_vdd inh_vdds) LVT_NOR2x1_PB4_AFBB
    U377 (n362 n361 n346 inh_gnd inh_gnds inh_vdd inh_vdds) LVT_NOR2x1_PB4_AFBB
    U382 (B\<30\> n188 n365 inh_gnd inh_gnds inh_vdd inh_vdds) LVT_NOR2x1_PB4_AFBB
    U374 (n127 n356 n355 inh_gnd inh_gnds inh_vdd inh_vdds) LVT_NOR2x1_PB4_AFBB
    U380 (A\<30\> n188 n364 inh_gnd inh_gnds inh_vdd inh_vdds) LVT_NOR2x1_PB4_AFBB
    U373 (n142 n354 n353 inh_gnd inh_gnds inh_vdd inh_vdds) LVT_NOR2x1_PB4_AFBB
    U370 (n143 n23 n350 inh_gnd inh_gnds inh_vdd inh_vdds) LVT_NOR2x1_PB4_AFBB
    U372 (n351 n352 n345 inh_gnd inh_gnds inh_vdd inh_vdds) LVT_NOR2x1_PB4_AFBB
    U378 (n350 n137 n363 inh_gnd inh_gnds inh_vdd inh_vdds) LVT_NOR2x1_PB4_AFBB
    U371 (n347 n348 n351 inh_gnd inh_gnds inh_vdd inh_vdds) LVT_NOR2x1_PB4_AFBB
    U358 (B\<27\> A\<27\> n342 inh_gnd inh_gnds inh_vdd inh_vdds) LVT_NOR2x1_PB4_AFBB
    U349 (n189 n334 n333 inh_gnd inh_gnds inh_vdd inh_vdds) LVT_NOR2x1_PB4_AFBB
    U350 (n336 n144 n335 inh_gnd inh_gnds inh_vdd inh_vdds) LVT_NOR2x1_PB4_AFBB
    U363 (n335 n333 n344 inh_gnd inh_gnds inh_vdd inh_vdds) LVT_NOR2x1_PB4_AFBB
    U361 (n329 n331 n343 inh_gnd inh_gnds inh_vdd inh_vdds) LVT_NOR2x1_PB4_AFBB
    U351 (n338 n337 n322 inh_gnd inh_gnds inh_vdd inh_vdds) LVT_NOR2x1_PB4_AFBB
    U356 (B\<27\> n190 n341 inh_gnd inh_gnds inh_vdd inh_vdds) LVT_NOR2x1_PB4_AFBB
    U348 (n116 n332 n331 inh_gnd inh_gnds inh_vdd inh_vdds) LVT_NOR2x1_PB4_AFBB
    U354 (A\<27\> n190 n340 inh_gnd inh_gnds inh_vdd inh_vdds) LVT_NOR2x1_PB4_AFBB
    U347 (n145 n330 n329 inh_gnd inh_gnds inh_vdd inh_vdds) LVT_NOR2x1_PB4_AFBB
    U344 (n189 n146 n326 inh_gnd inh_gnds inh_vdd inh_vdds) LVT_NOR2x1_PB4_AFBB
    U346 (n327 n328 n321 inh_gnd inh_gnds inh_vdd inh_vdds) LVT_NOR2x1_PB4_AFBB
    U352 (n326 n132 n339 inh_gnd inh_gnds inh_vdd inh_vdds) LVT_NOR2x1_PB4_AFBB
    U345 (n323 n324 n327 inh_gnd inh_gnds inh_vdd inh_vdds) LVT_NOR2x1_PB4_AFBB
    U332 (B\<24\> A\<24\> n318 inh_gnd inh_gnds inh_vdd inh_vdds) LVT_NOR2x1_PB4_AFBB
    U323 (n191 n310 n309 inh_gnd inh_gnds inh_vdd inh_vdds) LVT_NOR2x1_PB4_AFBB
    U324 (n312 n147 n311 inh_gnd inh_gnds inh_vdd inh_vdds) LVT_NOR2x1_PB4_AFBB
    U337 (n311 n309 n320 inh_gnd inh_gnds inh_vdd inh_vdds) LVT_NOR2x1_PB4_AFBB
    U335 (n305 n307 n319 inh_gnd inh_gnds inh_vdd inh_vdds) LVT_NOR2x1_PB4_AFBB
    U325 (n314 n313 n298 inh_gnd inh_gnds inh_vdd inh_vdds) LVT_NOR2x1_PB4_AFBB
    U330 (B\<24\> n192 n317 inh_gnd inh_gnds inh_vdd inh_vdds) LVT_NOR2x1_PB4_AFBB
    U322 (n118 n308 n307 inh_gnd inh_gnds inh_vdd inh_vdds) LVT_NOR2x1_PB4_AFBB
    U328 (A\<24\> n192 n316 inh_gnd inh_gnds inh_vdd inh_vdds) LVT_NOR2x1_PB4_AFBB
    U321 (n148 n306 n305 inh_gnd inh_gnds inh_vdd inh_vdds) LVT_NOR2x1_PB4_AFBB
    U318 (n191 n149 n302 inh_gnd inh_gnds inh_vdd inh_vdds) LVT_NOR2x1_PB4_AFBB
    U320 (n303 n304 n297 inh_gnd inh_gnds inh_vdd inh_vdds) LVT_NOR2x1_PB4_AFBB
    U326 (n302 n131 n315 inh_gnd inh_gnds inh_vdd inh_vdds) LVT_NOR2x1_PB4_AFBB
    U319 (n299 n300 n303 inh_gnd inh_gnds inh_vdd inh_vdds) LVT_NOR2x1_PB4_AFBB
    U306 (B\<21\> A\<21\> n294 inh_gnd inh_gnds inh_vdd inh_vdds) LVT_NOR2x1_PB4_AFBB
    U297 (n193 n286 n285 inh_gnd inh_gnds inh_vdd inh_vdds) LVT_NOR2x1_PB4_AFBB
    U298 (n288 n150 n287 inh_gnd inh_gnds inh_vdd inh_vdds) LVT_NOR2x1_PB4_AFBB
    U311 (n287 n285 n296 inh_gnd inh_gnds inh_vdd inh_vdds) LVT_NOR2x1_PB4_AFBB
    U309 (n281 n283 n295 inh_gnd inh_gnds inh_vdd inh_vdds) LVT_NOR2x1_PB4_AFBB
    U299 (n290 n289 n274 inh_gnd inh_gnds inh_vdd inh_vdds) LVT_NOR2x1_PB4_AFBB
    U304 (B\<21\> n194 n293 inh_gnd inh_gnds inh_vdd inh_vdds) LVT_NOR2x1_PB4_AFBB
    U296 (n120 n284 n283 inh_gnd inh_gnds inh_vdd inh_vdds) LVT_NOR2x1_PB4_AFBB
    U302 (A\<21\> n194 n292 inh_gnd inh_gnds inh_vdd inh_vdds) LVT_NOR2x1_PB4_AFBB
    U295 (n151 n282 n281 inh_gnd inh_gnds inh_vdd inh_vdds) LVT_NOR2x1_PB4_AFBB
    U292 (n193 n152 n278 inh_gnd inh_gnds inh_vdd inh_vdds) LVT_NOR2x1_PB4_AFBB
    U300 (n278 n130 n291 inh_gnd inh_gnds inh_vdd inh_vdds) LVT_NOR2x1_PB4_AFBB
    U391 (n199 n370 carry\<1\> inh_gnd inh_gnds inh_vdd inh_vdds) LVT_NOR2x1_PB4_AFBB
    U395 (A\<0\> n187 n373 inh_gnd inh_gnds inh_vdd inh_vdds) LVT_NOR2x1_PB4_AFBB
    U396 (B\<0\> n369 n374 inh_gnd inh_gnds inh_vdd inh_vdds) LVT_NOR2x1_PB4_AFBB
    U369 (n23 n126 n349 inh_gnd inh_gnds inh_vdd inh_vdds) LVT_NOR2x1_PB4_AFBB
    U343 (n189 n115 n325 inh_gnd inh_gnds inh_vdd inh_vdds) LVT_NOR2x1_PB4_AFBB
    U317 (n191 n117 n301 inh_gnd inh_gnds inh_vdd inh_vdds) LVT_NOR2x1_PB4_AFBB
    U291 (n193 n119 n277 inh_gnd inh_gnds inh_vdd inh_vdds) LVT_NOR2x1_PB4_AFBB
    U294 (n279 n280 n273 inh_gnd inh_gnds inh_vdd inh_vdds) LVT_NOR2x1_PB4_AFBB
    U293 (n275 n276 n279 inh_gnd inh_gnds inh_vdd inh_vdds) LVT_NOR2x1_PB4_AFBB
    U280 (B\<18\> A\<18\> n270 inh_gnd inh_gnds inh_vdd inh_vdds) LVT_NOR2x1_PB4_AFBB
    U271 (n195 n262 n261 inh_gnd inh_gnds inh_vdd inh_vdds) LVT_NOR2x1_PB4_AFBB
    U272 (n264 n153 n263 inh_gnd inh_gnds inh_vdd inh_vdds) LVT_NOR2x1_PB4_AFBB
    U285 (n263 n261 n272 inh_gnd inh_gnds inh_vdd inh_vdds) LVT_NOR2x1_PB4_AFBB
    U283 (n257 n259 n271 inh_gnd inh_gnds inh_vdd inh_vdds) LVT_NOR2x1_PB4_AFBB
    U273 (n266 n265 n250 inh_gnd inh_gnds inh_vdd inh_vdds) LVT_NOR2x1_PB4_AFBB
    U278 (B\<18\> n196 n269 inh_gnd inh_gnds inh_vdd inh_vdds) LVT_NOR2x1_PB4_AFBB
    U270 (n122 n260 n259 inh_gnd inh_gnds inh_vdd inh_vdds) LVT_NOR2x1_PB4_AFBB
    U276 (A\<18\> n196 n268 inh_gnd inh_gnds inh_vdd inh_vdds) LVT_NOR2x1_PB4_AFBB
    U269 (n154 n258 n257 inh_gnd inh_gnds inh_vdd inh_vdds) LVT_NOR2x1_PB4_AFBB
    U266 (n195 n155 n254 inh_gnd inh_gnds inh_vdd inh_vdds) LVT_NOR2x1_PB4_AFBB
    U268 (n255 n256 n249 inh_gnd inh_gnds inh_vdd inh_vdds) LVT_NOR2x1_PB4_AFBB
    U274 (n254 n129 n267 inh_gnd inh_gnds inh_vdd inh_vdds) LVT_NOR2x1_PB4_AFBB
    U267 (n251 n252 n255 inh_gnd inh_gnds inh_vdd inh_vdds) LVT_NOR2x1_PB4_AFBB
    U254 (B\<15\> A\<15\> n246 inh_gnd inh_gnds inh_vdd inh_vdds) LVT_NOR2x1_PB4_AFBB
    U245 (n197 n238 n237 inh_gnd inh_gnds inh_vdd inh_vdds) LVT_NOR2x1_PB4_AFBB
    U246 (n240 n156 n239 inh_gnd inh_gnds inh_vdd inh_vdds) LVT_NOR2x1_PB4_AFBB
    U259 (n239 n237 n248 inh_gnd inh_gnds inh_vdd inh_vdds) LVT_NOR2x1_PB4_AFBB
    U257 (n233 n235 n247 inh_gnd inh_gnds inh_vdd inh_vdds) LVT_NOR2x1_PB4_AFBB
    U247 (n242 n241 n226 inh_gnd inh_gnds inh_vdd inh_vdds) LVT_NOR2x1_PB4_AFBB
    U252 (B\<15\> n198 n245 inh_gnd inh_gnds inh_vdd inh_vdds) LVT_NOR2x1_PB4_AFBB
    U244 (n124 n236 n235 inh_gnd inh_gnds inh_vdd inh_vdds) LVT_NOR2x1_PB4_AFBB
    U250 (A\<15\> n198 n244 inh_gnd inh_gnds inh_vdd inh_vdds) LVT_NOR2x1_PB4_AFBB
    U243 (n157 n234 n233 inh_gnd inh_gnds inh_vdd inh_vdds) LVT_NOR2x1_PB4_AFBB
    U240 (n197 n158 n230 inh_gnd inh_gnds inh_vdd inh_vdds) LVT_NOR2x1_PB4_AFBB
    U242 (n231 n232 n225 inh_gnd inh_gnds inh_vdd inh_vdds) LVT_NOR2x1_PB4_AFBB
    U248 (n230 n128 n243 inh_gnd inh_gnds inh_vdd inh_vdds) LVT_NOR2x1_PB4_AFBB
    U241 (n227 n228 n231 inh_gnd inh_gnds inh_vdd inh_vdds) LVT_NOR2x1_PB4_AFBB
    U227 (B\<12\> A\<12\> n221 inh_gnd inh_gnds inh_vdd inh_vdds) LVT_NOR2x1_PB4_AFBB
    U218 (n202 n213 n212 inh_gnd inh_gnds inh_vdd inh_vdds) LVT_NOR2x1_PB4_AFBB
    U219 (n140 n215 n214 inh_gnd inh_gnds inh_vdd inh_vdds) LVT_NOR2x1_PB4_AFBB
    U233 (n214 n212 n224 inh_gnd inh_gnds inh_vdd inh_vdds) LVT_NOR2x1_PB4_AFBB
    U231 (n208 n210 n223 inh_gnd inh_gnds inh_vdd inh_vdds) LVT_NOR2x1_PB4_AFBB
    U220 (n217 n216 n201 inh_gnd inh_gnds inh_vdd inh_vdds) LVT_NOR2x1_PB4_AFBB
    U225 (B\<12\> carry\<12\> n220 inh_gnd inh_gnds inh_vdd inh_vdds) LVT_NOR2x1_PB4_AFBB
    U217 (n203 n211 n210 inh_gnd inh_gnds inh_vdd inh_vdds) LVT_NOR2x1_PB4_AFBB
    U223 (A\<12\> carry\<12\> n219 inh_gnd inh_gnds inh_vdd inh_vdds) LVT_NOR2x1_PB4_AFBB
    U216 (n138 n209 n208 inh_gnd inh_gnds inh_vdd inh_vdds) LVT_NOR2x1_PB4_AFBB
    U213 (n202 n204 n205 inh_gnd inh_gnds inh_vdd inh_vdds) LVT_NOR2x1_PB4_AFBB
    U215 (n206 n207 n200 inh_gnd inh_gnds inh_vdd inh_vdds) LVT_NOR2x1_PB4_AFBB
    U221 (n205 n125 n218 inh_gnd inh_gnds inh_vdd inh_vdds) LVT_NOR2x1_PB4_AFBB
    U214 (n161 n139 n206 inh_gnd inh_gnds inh_vdd inh_vdds) LVT_NOR2x1_PB4_AFBB
    U188 (B\<11\> A\<11\> n184 inh_gnd inh_gnds inh_vdd inh_vdds) LVT_NOR2x1_PB4_AFBB
    U179 (n159 n176 n175 inh_gnd inh_gnds inh_vdd inh_vdds) LVT_NOR2x1_PB4_AFBB
    U180 (n178 n134 n177 inh_gnd inh_gnds inh_vdd inh_vdds) LVT_NOR2x1_PB4_AFBB
    U193 (n177 n175 n186 inh_gnd inh_gnds inh_vdd inh_vdds) LVT_NOR2x1_PB4_AFBB
    U191 (n171 n173 n185 inh_gnd inh_gnds inh_vdd inh_vdds) LVT_NOR2x1_PB4_AFBB
    U181 (n180 n179 n164 inh_gnd inh_gnds inh_vdd inh_vdds) LVT_NOR2x1_PB4_AFBB
    U186 (B\<11\> n160 n183 inh_gnd inh_gnds inh_vdd inh_vdds) LVT_NOR2x1_PB4_AFBB
    U178 (n114 n174 n173 inh_gnd inh_gnds inh_vdd inh_vdds) LVT_NOR2x1_PB4_AFBB
    U184 (A\<11\> n160 n182 inh_gnd inh_gnds inh_vdd inh_vdds) LVT_NOR2x1_PB4_AFBB
    U177 (n135 n172 n171 inh_gnd inh_gnds inh_vdd inh_vdds) LVT_NOR2x1_PB4_AFBB
    U174 (n136 n159 n168 inh_gnd inh_gnds inh_vdd inh_vdds) LVT_NOR2x1_PB4_AFBB
    U176 (n169 n170 n163 inh_gnd inh_gnds inh_vdd inh_vdds) LVT_NOR2x1_PB4_AFBB
    U182 (n168 n133 n181 inh_gnd inh_gnds inh_vdd inh_vdds) LVT_NOR2x1_PB4_AFBB
    U175 (n165 n166 n169 inh_gnd inh_gnds inh_vdd inh_vdds) LVT_NOR2x1_PB4_AFBB
    U265 (n195 n121 n253 inh_gnd inh_gnds inh_vdd inh_vdds) LVT_NOR2x1_PB4_AFBB
    U239 (n197 n123 n229 inh_gnd inh_gnds inh_vdd inh_vdds) LVT_NOR2x1_PB4_AFBB
    U229 (n202 n162 n222 inh_gnd inh_gnds inh_vdd inh_vdds) LVT_NOR2x1_PB4_AFBB
    U173 (n113 n159 n167 inh_gnd inh_gnds inh_vdd inh_vdds) LVT_NOR2x1_PB4_AFBB
    U112 (B\<9\> A\<9\> n110 inh_gnd inh_gnds inh_vdd inh_vdds) LVT_NOR2x1_PB4_AFBB
    U110 (B\<9\> n88 n109 inh_gnd inh_gnds inh_vdd inh_vdds) LVT_NOR2x1_PB4_AFBB
    U115 (n97 n99 n111 inh_gnd inh_gnds inh_vdd inh_vdds) LVT_NOR2x1_PB4_AFBB
    U102 (n92 n100 n99 inh_gnd inh_gnds inh_vdd inh_vdds) LVT_NOR2x1_PB4_AFBB
    U105 (n105 n106 n90 inh_gnd inh_gnds inh_vdd inh_vdds) LVT_NOR2x1_PB4_AFBB
    U103 (n91 n102 n101 inh_gnd inh_gnds inh_vdd inh_vdds) LVT_NOR2x1_PB4_AFBB
    U104 (n29 n104 n103 inh_gnd inh_gnds inh_vdd inh_vdds) LVT_NOR2x1_PB4_AFBB
    U117 (n101 n103 n112 inh_gnd inh_gnds inh_vdd inh_vdds) LVT_NOR2x1_PB4_AFBB
    U108 (A\<9\> n88 n108 inh_gnd inh_gnds inh_vdd inh_vdds) LVT_NOR2x1_PB4_AFBB
    U101 (n15 n98 n97 inh_gnd inh_gnds inh_vdd inh_vdds) LVT_NOR2x1_PB4_AFBB
    U98 (n30 n33 n94 inh_gnd inh_gnds inh_vdd inh_vdds) LVT_NOR2x1_PB4_AFBB
    U100 (n95 n96 n89 inh_gnd inh_gnds inh_vdd inh_vdds) LVT_NOR2x1_PB4_AFBB
    U106 (n24 n94 n107 inh_gnd inh_gnds inh_vdd inh_vdds) LVT_NOR2x1_PB4_AFBB
    U99 (n19 n16 n95 inh_gnd inh_gnds inh_vdd inh_vdds) LVT_NOR2x1_PB4_AFBB
    U83 (B\<6\> A\<6\> n83 inh_gnd inh_gnds inh_vdd inh_vdds) LVT_NOR2x1_PB4_AFBB
    U74 (n64 n75 n74 inh_gnd inh_gnds inh_vdd inh_vdds) LVT_NOR2x1_PB4_AFBB
    U75 (n27 n77 n76 inh_gnd inh_gnds inh_vdd inh_vdds) LVT_NOR2x1_PB4_AFBB
    U88 (n74 n76 n85 inh_gnd inh_gnds inh_vdd inh_vdds) LVT_NOR2x1_PB4_AFBB
    U86 (n70 n72 n84 inh_gnd inh_gnds inh_vdd inh_vdds) LVT_NOR2x1_PB4_AFBB
    U76 (n78 n79 n63 inh_gnd inh_gnds inh_vdd inh_vdds) LVT_NOR2x1_PB4_AFBB
    U81 (B\<6\> n37 n82 inh_gnd inh_gnds inh_vdd inh_vdds) LVT_NOR2x1_PB4_AFBB
    U73 (n65 n73 n72 inh_gnd inh_gnds inh_vdd inh_vdds) LVT_NOR2x1_PB4_AFBB
    U79 (A\<6\> n37 n81 inh_gnd inh_gnds inh_vdd inh_vdds) LVT_NOR2x1_PB4_AFBB
    U72 (n13 n71 n70 inh_gnd inh_gnds inh_vdd inh_vdds) LVT_NOR2x1_PB4_AFBB
    U69 (n28 n34 n67 inh_gnd inh_gnds inh_vdd inh_vdds) LVT_NOR2x1_PB4_AFBB
    U71 (n68 n69 n62 inh_gnd inh_gnds inh_vdd inh_vdds) LVT_NOR2x1_PB4_AFBB
    U77 (n26 n67 n80 inh_gnd inh_gnds inh_vdd inh_vdds) LVT_NOR2x1_PB4_AFBB
    U70 (n17 n14 n68 inh_gnd inh_gnds inh_vdd inh_vdds) LVT_NOR2x1_PB4_AFBB
    U56 (B\<7\> A\<7\> n58 inh_gnd inh_gnds inh_vdd inh_vdds) LVT_NOR2x1_PB4_AFBB
    U47 (n40 n50 n49 inh_gnd inh_gnds inh_vdd inh_vdds) LVT_NOR2x1_PB4_AFBB
    U49 (n53 n54 n39 inh_gnd inh_gnds inh_vdd inh_vdds) LVT_NOR2x1_PB4_AFBB
    U48 (n31 n52 n51 inh_gnd inh_gnds inh_vdd inh_vdds) LVT_NOR2x1_PB4_AFBB
    U62 (n49 n51 n61 inh_gnd inh_gnds inh_vdd inh_vdds) LVT_NOR2x1_PB4_AFBB
    U60 (n45 n47 n60 inh_gnd inh_gnds inh_vdd inh_vdds) LVT_NOR2x1_PB4_AFBB
    U45 (n32 n46 n45 inh_gnd inh_gnds inh_vdd inh_vdds) LVT_NOR2x1_PB4_AFBB
    U52 (A\<7\> carry\<7\> n56 inh_gnd inh_gnds inh_vdd inh_vdds) LVT_NOR2x1_PB4_AFBB
    U54 (B\<7\> carry\<7\> n57 inh_gnd inh_gnds inh_vdd inh_vdds) LVT_NOR2x1_PB4_AFBB
    U46 (n41 n48 n47 inh_gnd inh_gnds inh_vdd inh_vdds) LVT_NOR2x1_PB4_AFBB
    U43 (n21 n32 n43 inh_gnd inh_gnds inh_vdd inh_vdds) LVT_NOR2x1_PB4_AFBB
    U44 (n43 n44 n38 inh_gnd inh_gnds inh_vdd inh_vdds) LVT_NOR2x1_PB4_AFBB
    U42 (n31 n40 n42 inh_gnd inh_gnds inh_vdd inh_vdds) LVT_NOR2x1_PB4_AFBB
    U50 (n25 n42 n55 inh_gnd inh_gnds inh_vdd inh_vdds) LVT_NOR2x1_PB4_AFBB
    U97 (n33 n20 n93 inh_gnd inh_gnds inh_vdd inh_vdds) LVT_NOR2x1_PB4_AFBB
    U68 (n34 n18 n66 inh_gnd inh_gnds inh_vdd inh_vdds) LVT_NOR2x1_PB4_AFBB
    U58 (n40 n22 n59 inh_gnd inh_gnds inh_vdd inh_vdds) LVT_NOR2x1_PB4_AFBB
    U394 (n371 n372 SUM\<0\> inh_gnd inh_gnds inh_vdd inh_vdds) LVT_NADN2x1_PB4_AFBB
ends alu_adder_DW01_add_0

// power_gating_fine/alu_adder/schematic
subckt alu_adder pwr_en A\<31\> A\<30\> A\<29\> A\<28\> A\<27\> A\<26\> A\<25\> A\<24\> A\<23\> A\<22\> A\<21\> A\<20\> A\<19\> A\<18\> A\<17\> A\<16\> A\<15\> A\<14\> A\<13\> A\<12\> A\<11\> A\<10\> A\<9\> A\<8\> A\<7\> A\<6\> A\<5\> A\<4\> A\<3\> A\<2\> A\<1\> A\<0\> B\<31\> B\<30\> B\<29\> B\<28\> B\<27\> B\<26\> B\<25\> B\<24\> B\<23\> B\<22\> B\<21\> B\<20\> B\<19\> B\<18\> B\<17\> B\<16\> B\<15\> B\<14\> B\<13\> B\<12\> B\<11\> B\<10\> B\<9\> B\<8\> B\<7\> B\<6\> B\<5\> B\<4\> B\<3\> B\<2\> B\<1\> B\<0\> C\<31\> C\<30\> C\<29\> C\<28\> C\<27\> C\<26\> C\<25\> C\<24\> C\<23\> C\<22\> C\<21\> C\<20\> C\<19\> C\<18\> C\<17\> C\<16\> C\<15\> C\<14\> C\<13\> C\<12\> C\<11\> C\<10\> C\<9\> C\<8\> C\<7\> C\<6\> C\<5\> C\<4\> C\<3\> C\<2\> C\<1\> C\<0\> inh_gnd inh_gnds vdd_in inh_vdds
    U160 (pwr_en pwr_en_bar inh_gnd inh_gnds vdd_in inh_vdds) LVT_invx2_PB4_AFBB
    alu_adder_pwr_pmos (inh_vdd pwr_en_bar vdd_in inh_vdds) lvtpfet w=8000n l=30.00n nf=(2)*(1) ngcon=1 nsig_delvto_uo1=0 nsig_delvto_uo2=0 soa=1 swshe=0 swacc=0 swrg=0 swrsub=0 mismatch=1 m=1
    add_21 (A\<31\> A\<30\> A\<29\> A\<28\> A\<27\> A\<26\> A\<25\> A\<24\> A\<23\> A\<22\> A\<21\> A\<20\> A\<19\> A\<18\> A\<17\> A\<16\> A\<15\> A\<14\> A\<13\> A\<12\> A\<11\> A\<10\> A\<9\> A\<8\> A\<7\> A\<6\> A\<5\> A\<4\> A\<3\> A\<2\> A\<1\> A\<0\> B\<31\> B\<30\> B\<29\> B\<28\> B\<27\> B\<26\> B\<25\> B\<24\> B\<23\> B\<22\> B\<21\> B\<20\> B\<19\> B\<18\> B\<17\> B\<16\> B\<15\> B\<14\> B\<13\> B\<12\> B\<11\> B\<10\> B\<9\> B\<8\> B\<7\> B\<6\> B\<5\> B\<4\> B\<3\> B\<2\> B\<1\> B\<0\> GND! addition\<31\> addition\<30\> addition\<29\> addition\<28\> addition\<27\> addition\<26\> addition\<25\> addition\<24\> addition\<23\> addition\<22\> addition\<21\> addition\<20\> addition\<19\> addition\<18\> addition\<17\> addition\<16\> addition\<15\> addition\<14\> addition\<13\> addition\<12\> addition\<11\> addition\<10\> addition\<9\> addition\<8\> addition\<7\> addition\<6\> addition\<5\> addition\<4\> addition\<3\> addition\<2\> addition\<1\> addition\<0\> NeTt_135 inh_gnd inh_gnds inh_vdd inh_vdds) alu_adder_DW01_add_0
    Thru31 (addition\<0\> C\<0\>) iprobe
    Thru30 (addition\<1\> C\<1\>) iprobe
    Thru29 (addition\<2\> C\<2\>) iprobe
    Thru28 (addition\<3\> C\<3\>) iprobe
    Thru27 (addition\<4\> C\<4\>) iprobe
    Thru26 (addition\<5\> C\<5\>) iprobe
    Thru25 (addition\<6\> C\<6\>) iprobe
    Thru24 (addition\<7\> C\<7\>) iprobe
    Thru23 (addition\<8\> C\<8\>) iprobe
    Thru22 (addition\<9\> C\<9\>) iprobe
    Thru21 (addition\<10\> C\<10\>) iprobe
    Thru20 (addition\<11\> C\<11\>) iprobe
    Thru19 (addition\<12\> C\<12\>) iprobe
    Thru18 (addition\<13\> C\<13\>) iprobe
    Thru17 (addition\<14\> C\<14\>) iprobe
    Thru16 (addition\<15\> C\<15\>) iprobe
    Thru15 (addition\<16\> C\<16\>) iprobe
    Thru14 (addition\<17\> C\<17\>) iprobe
    Thru13 (addition\<18\> C\<18\>) iprobe
    Thru12 (addition\<19\> C\<19\>) iprobe
    Thru11 (addition\<20\> C\<20\>) iprobe
    Thru10 (addition\<21\> C\<21\>) iprobe
    Thru9 (addition\<22\> C\<22\>) iprobe
    Thru8 (addition\<23\> C\<23\>) iprobe
    Thru7 (addition\<24\> C\<24\>) iprobe
    Thru6 (addition\<25\> C\<25\>) iprobe
    Thru5 (addition\<26\> C\<26\>) iprobe
    Thru4 (addition\<27\> C\<27\>) iprobe
    Thru3 (addition\<28\> C\<28\>) iprobe
    Thru2 (addition\<29\> C\<29\>) iprobe
    Thru1 (addition\<30\> C\<30\>) iprobe
    Thru0 (addition\<31\> C\<31\>) iprobe
ends alu_adder

// power_gating_fine/alu_subtractor_DW01_sub_0/schematic
subckt alu_subtractor_DW01_sub_0 A\<31\> A\<30\> A\<29\> A\<28\> A\<27\> A\<26\> A\<25\> A\<24\> A\<23\> A\<22\> A\<21\> A\<20\> A\<19\> A\<18\> A\<17\> A\<16\> A\<15\> A\<14\> A\<13\> A\<12\> A\<11\> A\<10\> A\<9\> A\<8\> A\<7\> A\<6\> A\<5\> A\<4\> A\<3\> A\<2\> A\<1\> A\<0\> B\<31\> B\<30\> B\<29\> B\<28\> B\<27\> B\<26\> B\<25\> B\<24\> B\<23\> B\<22\> B\<21\> B\<20\> B\<19\> B\<18\> B\<17\> B\<16\> B\<15\> B\<14\> B\<13\> B\<12\> B\<11\> B\<10\> B\<9\> B\<8\> B\<7\> B\<6\> B\<5\> B\<4\> B\<3\> B\<2\> B\<1\> B\<0\> CI DIFF\<31\> DIFF\<30\> DIFF\<29\> DIFF\<28\> DIFF\<27\> DIFF\<26\> DIFF\<25\> DIFF\<24\> DIFF\<23\> DIFF\<22\> DIFF\<21\> DIFF\<20\> DIFF\<19\> DIFF\<18\> DIFF\<17\> DIFF\<16\> DIFF\<15\> DIFF\<14\> DIFF\<13\> DIFF\<12\> DIFF\<11\> DIFF\<10\> DIFF\<9\> DIFF\<8\> DIFF\<7\> DIFF\<6\> DIFF\<5\> DIFF\<4\> DIFF\<3\> DIFF\<2\> DIFF\<1\> DIFF\<0\> CO inh_gnd inh_gnds inh_vdd inh_vdds
    U361 (B\<11\> n342 inh_gnd inh_gnds inh_vdd inh_vdds) LVT_invx2_PB4_AFBB
    U177 (n175 n167 inh_gnd inh_gnds inh_vdd inh_vdds) LVT_invx2_PB4_AFBB
    U183 (n178 n171 inh_gnd inh_gnds inh_vdd inh_vdds) LVT_invx2_PB4_AFBB
    U160 (n157 DIFF\<11\> inh_gnd inh_gnds inh_vdd inh_vdds) LVT_invx2_PB4_AFBB
    U173 (n173 n163 inh_gnd inh_gnds inh_vdd inh_vdds) LVT_invx2_PB4_AFBB
    U181 (n177 n170 inh_gnd inh_gnds inh_vdd inh_vdds) LVT_invx2_PB4_AFBB
    U161 (A\<11\> n158 inh_gnd inh_gnds inh_vdd inh_vdds) LVT_invx2_PB4_AFBB
    U175 (n174 n165 inh_gnd inh_gnds inh_vdd inh_vdds) LVT_invx2_PB4_AFBB
    U121 (B\<11\> n118 inh_gnd inh_gnds inh_vdd inh_vdds) LVT_invx2_PB4_AFBB
    U358 (B\<14\> n339 inh_gnd inh_gnds inh_vdd inh_vdds) LVT_invx2_PB4_AFBB
    U201 (n198 n189 inh_gnd inh_gnds inh_vdd inh_vdds) LVT_invx2_PB4_AFBB
    U131 (A\<14\> n128 inh_gnd inh_gnds inh_vdd inh_vdds) LVT_invx2_PB4_AFBB
    U206 (n200 n194 inh_gnd inh_gnds inh_vdd inh_vdds) LVT_invx2_PB4_AFBB
    U199 (n197 n187 inh_gnd inh_gnds inh_vdd inh_vdds) LVT_invx2_PB4_AFBB
    U185 (n180 DIFF\<14\> inh_gnd inh_gnds inh_vdd inh_vdds) LVT_invx2_PB4_AFBB
    U208 (n201 n195 inh_gnd inh_gnds inh_vdd inh_vdds) LVT_invx2_PB4_AFBB
    U203 (n199 n191 inh_gnd inh_gnds inh_vdd inh_vdds) LVT_invx2_PB4_AFBB
    U142 (B\<14\> n139 inh_gnd inh_gnds inh_vdd inh_vdds) LVT_invx2_PB4_AFBB
    U355 (B\<17\> n336 inh_gnd inh_gnds inh_vdd inh_vdds) LVT_invx2_PB4_AFBB
    U226 (n221 n212 inh_gnd inh_gnds inh_vdd inh_vdds) LVT_invx2_PB4_AFBB
    U129 (A\<17\> n126 inh_gnd inh_gnds inh_vdd inh_vdds) LVT_invx2_PB4_AFBB
    U231 (n223 n217 inh_gnd inh_gnds inh_vdd inh_vdds) LVT_invx2_PB4_AFBB
    U224 (n220 n210 inh_gnd inh_gnds inh_vdd inh_vdds) LVT_invx2_PB4_AFBB
    U210 (n203 DIFF\<17\> inh_gnd inh_gnds inh_vdd inh_vdds) LVT_invx2_PB4_AFBB
    U233 (n224 n218 inh_gnd inh_gnds inh_vdd inh_vdds) LVT_invx2_PB4_AFBB
    U228 (n222 n214 inh_gnd inh_gnds inh_vdd inh_vdds) LVT_invx2_PB4_AFBB
    U141 (B\<17\> n138 inh_gnd inh_gnds inh_vdd inh_vdds) LVT_invx2_PB4_AFBB
    U352 (B\<20\> n333 inh_gnd inh_gnds inh_vdd inh_vdds) LVT_invx2_PB4_AFBB
    U251 (n244 n235 inh_gnd inh_gnds inh_vdd inh_vdds) LVT_invx2_PB4_AFBB
    U127 (A\<20\> n124 inh_gnd inh_gnds inh_vdd inh_vdds) LVT_invx2_PB4_AFBB
    U256 (n246 n240 inh_gnd inh_gnds inh_vdd inh_vdds) LVT_invx2_PB4_AFBB
    U249 (n243 n233 inh_gnd inh_gnds inh_vdd inh_vdds) LVT_invx2_PB4_AFBB
    U235 (n226 DIFF\<20\> inh_gnd inh_gnds inh_vdd inh_vdds) LVT_invx2_PB4_AFBB
    U258 (n247 n241 inh_gnd inh_gnds inh_vdd inh_vdds) LVT_invx2_PB4_AFBB
    U253 (n245 n237 inh_gnd inh_gnds inh_vdd inh_vdds) LVT_invx2_PB4_AFBB
    U140 (B\<20\> n137 inh_gnd inh_gnds inh_vdd inh_vdds) LVT_invx2_PB4_AFBB
    U349 (B\<23\> n330 inh_gnd inh_gnds inh_vdd inh_vdds) LVT_invx2_PB4_AFBB
    U276 (n267 n258 inh_gnd inh_gnds inh_vdd inh_vdds) LVT_invx2_PB4_AFBB
    U125 (A\<23\> n122 inh_gnd inh_gnds inh_vdd inh_vdds) LVT_invx2_PB4_AFBB
    U281 (n269 n263 inh_gnd inh_gnds inh_vdd inh_vdds) LVT_invx2_PB4_AFBB
    U274 (n266 n256 inh_gnd inh_gnds inh_vdd inh_vdds) LVT_invx2_PB4_AFBB
    U260 (n249 DIFF\<23\> inh_gnd inh_gnds inh_vdd inh_vdds) LVT_invx2_PB4_AFBB
    U283 (n270 n264 inh_gnd inh_gnds inh_vdd inh_vdds) LVT_invx2_PB4_AFBB
    U152 (n148 n149 inh_gnd inh_gnds inh_vdd inh_vdds) LVT_invx2_PB4_AFBB
    U278 (n268 n260 inh_gnd inh_gnds inh_vdd inh_vdds) LVT_invx2_PB4_AFBB
    U139 (B\<23\> n136 inh_gnd inh_gnds inh_vdd inh_vdds) LVT_invx2_PB4_AFBB
    U367 (B\<2\> n348 inh_gnd inh_gnds inh_vdd inh_vdds) LVT_invx2_PB4_AFBB
    U369 (B\<0\> n350 inh_gnd inh_gnds inh_vdd inh_vdds) LVT_invx2_PB4_AFBB
    U335 (n318 carry\<1\> inh_gnd inh_gnds inh_vdd inh_vdds) LVT_invx2_PB4_AFBB
    U366 (B\<3\> n347 inh_gnd inh_gnds inh_vdd inh_vdds) LVT_invx2_PB4_AFBB
    U365 (B\<4\> n346 inh_gnd inh_gnds inh_vdd inh_vdds) LVT_invx2_PB4_AFBB
    U364 (B\<5\> n345 inh_gnd inh_gnds inh_vdd inh_vdds) LVT_invx2_PB4_AFBB
    U359 (B\<13\> n340 inh_gnd inh_gnds inh_vdd inh_vdds) LVT_invx2_PB4_AFBB
    U356 (B\<16\> n337 inh_gnd inh_gnds inh_vdd inh_vdds) LVT_invx2_PB4_AFBB
    U353 (B\<19\> n334 inh_gnd inh_gnds inh_vdd inh_vdds) LVT_invx2_PB4_AFBB
    U350 (B\<22\> n331 inh_gnd inh_gnds inh_vdd inh_vdds) LVT_invx2_PB4_AFBB
    U368 (B\<1\> n349 inh_gnd inh_gnds inh_vdd inh_vdds) LVT_invx2_PB4_AFBB
    U363 (B\<8\> n344 inh_gnd inh_gnds inh_vdd inh_vdds) LVT_invx2_PB4_AFBB
    U362 (B\<10\> n343 inh_gnd inh_gnds inh_vdd inh_vdds) LVT_invx2_PB4_AFBB
    U360 (B\<12\> n341 inh_gnd inh_gnds inh_vdd inh_vdds) LVT_invx2_PB4_AFBB
    U357 (B\<15\> n338 inh_gnd inh_gnds inh_vdd inh_vdds) LVT_invx2_PB4_AFBB
    U354 (B\<18\> n335 inh_gnd inh_gnds inh_vdd inh_vdds) LVT_invx2_PB4_AFBB
    U351 (B\<21\> n332 inh_gnd inh_gnds inh_vdd inh_vdds) LVT_invx2_PB4_AFBB
    U146 (n142 n143 inh_gnd inh_gnds inh_vdd inh_vdds) LVT_invx2_PB4_AFBB
    U145 (carry\<11\> n142 inh_gnd inh_gnds inh_vdd inh_vdds) LVT_invx2_PB4_AFBB
    U158 (n154 n155 inh_gnd inh_gnds inh_vdd inh_vdds) LVT_invx2_PB4_AFBB
    U157 (carry\<14\> n154 inh_gnd inh_gnds inh_vdd inh_vdds) LVT_invx2_PB4_AFBB
    U156 (n152 n153 inh_gnd inh_gnds inh_vdd inh_vdds) LVT_invx2_PB4_AFBB
    U155 (carry\<17\> n152 inh_gnd inh_gnds inh_vdd inh_vdds) LVT_invx2_PB4_AFBB
    U154 (n150 n151 inh_gnd inh_gnds inh_vdd inh_vdds) LVT_invx2_PB4_AFBB
    U153 (carry\<20\> n150 inh_gnd inh_gnds inh_vdd inh_vdds) LVT_invx2_PB4_AFBB
    U346 (B\<26\> n327 inh_gnd inh_gnds inh_vdd inh_vdds) LVT_invx2_PB4_AFBB
    U301 (n290 n281 inh_gnd inh_gnds inh_vdd inh_vdds) LVT_invx2_PB4_AFBB
    U123 (A\<26\> n120 inh_gnd inh_gnds inh_vdd inh_vdds) LVT_invx2_PB4_AFBB
    U306 (n292 n286 inh_gnd inh_gnds inh_vdd inh_vdds) LVT_invx2_PB4_AFBB
    U299 (n289 n279 inh_gnd inh_gnds inh_vdd inh_vdds) LVT_invx2_PB4_AFBB
    U285 (n272 DIFF\<26\> inh_gnd inh_gnds inh_vdd inh_vdds) LVT_invx2_PB4_AFBB
    U308 (n293 n287 inh_gnd inh_gnds inh_vdd inh_vdds) LVT_invx2_PB4_AFBB
    U303 (n291 n283 inh_gnd inh_gnds inh_vdd inh_vdds) LVT_invx2_PB4_AFBB
    U138 (B\<26\> n135 inh_gnd inh_gnds inh_vdd inh_vdds) LVT_invx2_PB4_AFBB
    U343 (B\<29\> n324 inh_gnd inh_gnds inh_vdd inh_vdds) LVT_invx2_PB4_AFBB
    U327 (n314 n305 inh_gnd inh_gnds inh_vdd inh_vdds) LVT_invx2_PB4_AFBB
    U134 (A\<29\> n131 inh_gnd inh_gnds inh_vdd inh_vdds) LVT_invx2_PB4_AFBB
    U332 (n316 n310 inh_gnd inh_gnds inh_vdd inh_vdds) LVT_invx2_PB4_AFBB
    U325 (n313 n303 inh_gnd inh_gnds inh_vdd inh_vdds) LVT_invx2_PB4_AFBB
    U310 (n295 DIFF\<29\> inh_gnd inh_gnds inh_vdd inh_vdds) LVT_invx2_PB4_AFBB
    U334 (n317 n311 inh_gnd inh_gnds inh_vdd inh_vdds) LVT_invx2_PB4_AFBB
    U329 (n315 n307 inh_gnd inh_gnds inh_vdd inh_vdds) LVT_invx2_PB4_AFBB
    U137 (B\<29\> n134 inh_gnd inh_gnds inh_vdd inh_vdds) LVT_invx2_PB4_AFBB
    U135 (n309 n132 inh_gnd inh_gnds inh_vdd inh_vdds) LVT_invx2_PB4_AFBB
    U323 (n312 n301 inh_gnd inh_gnds inh_vdd inh_vdds) LVT_invx2_PB4_AFBB
    U309 (n294 carry\<30\> inh_gnd inh_gnds inh_vdd inh_vdds) LVT_invx2_PB4_AFBB
    U312 (A\<29\> n297 inh_gnd inh_gnds inh_vdd inh_vdds) LVT_invx2_PB4_AFBB
    U337 (A\<0\> n319 inh_gnd inh_gnds inh_vdd inh_vdds) LVT_invx2_PB4_AFBB
    U136 (B\<0\> n133 inh_gnd inh_gnds inh_vdd inh_vdds) LVT_invx2_PB4_AFBB
    U120 (n285 n117 inh_gnd inh_gnds inh_vdd inh_vdds) LVT_invx2_PB4_AFBB
    U297 (n288 n277 inh_gnd inh_gnds inh_vdd inh_vdds) LVT_invx2_PB4_AFBB
    U284 (n271 carry\<27\> inh_gnd inh_gnds inh_vdd inh_vdds) LVT_invx2_PB4_AFBB
    U286 (A\<26\> n273 inh_gnd inh_gnds inh_vdd inh_vdds) LVT_invx2_PB4_AFBB
    U261 (A\<23\> n250 inh_gnd inh_gnds inh_vdd inh_vdds) LVT_invx2_PB4_AFBB
    U259 (n248 carry\<24\> inh_gnd inh_gnds inh_vdd inh_vdds) LVT_invx2_PB4_AFBB
    U272 (n265 n254 inh_gnd inh_gnds inh_vdd inh_vdds) LVT_invx2_PB4_AFBB
    U119 (n262 n116 inh_gnd inh_gnds inh_vdd inh_vdds) LVT_invx2_PB4_AFBB
    U279 (n251 n262 inh_gnd inh_gnds inh_vdd inh_vdds) LVT_invx2_PB4_AFBB
    U124 (A\<23\> n121 inh_gnd inh_gnds inh_vdd inh_vdds) LVT_invx2_PB4_AFBB
    U236 (A\<20\> n227 inh_gnd inh_gnds inh_vdd inh_vdds) LVT_invx2_PB4_AFBB
    U234 (n225 carry\<21\> inh_gnd inh_gnds inh_vdd inh_vdds) LVT_invx2_PB4_AFBB
    U247 (n242 n231 inh_gnd inh_gnds inh_vdd inh_vdds) LVT_invx2_PB4_AFBB
    U118 (n239 n115 inh_gnd inh_gnds inh_vdd inh_vdds) LVT_invx2_PB4_AFBB
    U254 (n228 n239 inh_gnd inh_gnds inh_vdd inh_vdds) LVT_invx2_PB4_AFBB
    U126 (A\<20\> n123 inh_gnd inh_gnds inh_vdd inh_vdds) LVT_invx2_PB4_AFBB
    U211 (A\<17\> n204 inh_gnd inh_gnds inh_vdd inh_vdds) LVT_invx2_PB4_AFBB
    U209 (n202 carry\<18\> inh_gnd inh_gnds inh_vdd inh_vdds) LVT_invx2_PB4_AFBB
    U222 (n219 n208 inh_gnd inh_gnds inh_vdd inh_vdds) LVT_invx2_PB4_AFBB
    U117 (n216 n114 inh_gnd inh_gnds inh_vdd inh_vdds) LVT_invx2_PB4_AFBB
    U229 (n205 n216 inh_gnd inh_gnds inh_vdd inh_vdds) LVT_invx2_PB4_AFBB
    U128 (A\<17\> n125 inh_gnd inh_gnds inh_vdd inh_vdds) LVT_invx2_PB4_AFBB
    U186 (A\<14\> n181 inh_gnd inh_gnds inh_vdd inh_vdds) LVT_invx2_PB4_AFBB
    U184 (n179 carry\<15\> inh_gnd inh_gnds inh_vdd inh_vdds) LVT_invx2_PB4_AFBB
    U197 (n196 n185 inh_gnd inh_gnds inh_vdd inh_vdds) LVT_invx2_PB4_AFBB
    U116 (n193 n113 inh_gnd inh_gnds inh_vdd inh_vdds) LVT_invx2_PB4_AFBB
    U204 (n182 n193 inh_gnd inh_gnds inh_vdd inh_vdds) LVT_invx2_PB4_AFBB
    U130 (A\<14\> n127 inh_gnd inh_gnds inh_vdd inh_vdds) LVT_invx2_PB4_AFBB
    U159 (n156 carry\<12\> inh_gnd inh_gnds inh_vdd inh_vdds) LVT_invx2_PB4_AFBB
    U171 (n172 n161 inh_gnd inh_gnds inh_vdd inh_vdds) LVT_invx2_PB4_AFBB
    U143 (A\<11\> n140 inh_gnd inh_gnds inh_vdd inh_vdds) LVT_invx2_PB4_AFBB
    U132 (n169 n129 inh_gnd inh_gnds inh_vdd inh_vdds) LVT_invx2_PB4_AFBB
    U179 (n176 n169 inh_gnd inh_gnds inh_vdd inh_vdds) LVT_invx2_PB4_AFBB
    U144 (A\<11\> n141 inh_gnd inh_gnds inh_vdd inh_vdds) LVT_invx2_PB4_AFBB
    U91 (n89 carry\<10\> inh_gnd inh_gnds inh_vdd inh_vdds) LVT_invx2_PB4_AFBB
    U103 (n106 n95 inh_gnd inh_gnds inh_vdd inh_vdds) LVT_invx2_PB4_AFBB
    U14 (A\<9\> n14 inh_gnd inh_gnds inh_vdd inh_vdds) LVT_invx2_PB4_AFBB
    U347 (B\<25\> n328 inh_gnd inh_gnds inh_vdd inh_vdds) LVT_invx2_PB4_AFBB
    U344 (B\<28\> n325 inh_gnd inh_gnds inh_vdd inh_vdds) LVT_invx2_PB4_AFBB
    U330 (n298 n309 inh_gnd inh_gnds inh_vdd inh_vdds) LVT_invx2_PB4_AFBB
    U133 (A\<29\> n130 inh_gnd inh_gnds inh_vdd inh_vdds) LVT_invx2_PB4_AFBB
    U341 (B\<31\> n322 inh_gnd inh_gnds inh_vdd inh_vdds) LVT_invx2_PB4_AFBB
    U304 (n274 n285 inh_gnd inh_gnds inh_vdd inh_vdds) LVT_invx2_PB4_AFBB
    U122 (A\<26\> n119 inh_gnd inh_gnds inh_vdd inh_vdds) LVT_invx2_PB4_AFBB
    U348 (B\<24\> n329 inh_gnd inh_gnds inh_vdd inh_vdds) LVT_invx2_PB4_AFBB
    U345 (B\<27\> n326 inh_gnd inh_gnds inh_vdd inh_vdds) LVT_invx2_PB4_AFBB
    U342 (B\<30\> n323 inh_gnd inh_gnds inh_vdd inh_vdds) LVT_invx2_PB4_AFBB
    U150 (n146 n147 inh_gnd inh_gnds inh_vdd inh_vdds) LVT_invx2_PB4_AFBB
    U149 (carry\<26\> n146 inh_gnd inh_gnds inh_vdd inh_vdds) LVT_invx2_PB4_AFBB
    U311 (n145 n296 inh_gnd inh_gnds inh_vdd inh_vdds) LVT_invx2_PB4_AFBB
    U148 (n144 n145 inh_gnd inh_gnds inh_vdd inh_vdds) LVT_invx2_PB4_AFBB
    U147 (carry\<29\> n144 inh_gnd inh_gnds inh_vdd inh_vdds) LVT_invx2_PB4_AFBB
    U151 (carry\<23\> n148 inh_gnd inh_gnds inh_vdd inh_vdds) LVT_invx2_PB4_AFBB
    U115 (n112 n105 inh_gnd inh_gnds inh_vdd inh_vdds) LVT_invx2_PB4_AFBB
    U90 (n90 DIFF\<9\> inh_gnd inh_gnds inh_vdd inh_vdds) LVT_invx2_PB4_AFBB
    U111 (n110 n103 inh_gnd inh_gnds inh_vdd inh_vdds) LVT_invx2_PB4_AFBB
    U25 (A\<9\> n25 inh_gnd inh_gnds inh_vdd inh_vdds) LVT_invx2_PB4_AFBB
    U109 (n109 n101 inh_gnd inh_gnds inh_vdd inh_vdds) LVT_invx2_PB4_AFBB
    U18 (B\<9\> n18 inh_gnd inh_gnds inh_vdd inh_vdds) LVT_invx2_PB4_AFBB
    U105 (n107 n97 inh_gnd inh_gnds inh_vdd inh_vdds) LVT_invx2_PB4_AFBB
    U113 (n111 n104 inh_gnd inh_gnds inh_vdd inh_vdds) LVT_invx2_PB4_AFBB
    U24 (A\<9\> n24 inh_gnd inh_gnds inh_vdd inh_vdds) LVT_invx2_PB4_AFBB
    U107 (n108 n99 inh_gnd inh_gnds inh_vdd inh_vdds) LVT_invx2_PB4_AFBB
    U19 (B\<9\> n19 inh_gnd inh_gnds inh_vdd inh_vdds) LVT_invx2_PB4_AFBB
    U61 (n62 DIFF\<6\> inh_gnd inh_gnds inh_vdd inh_vdds) LVT_invx2_PB4_AFBB
    U86 (n84 n77 inh_gnd inh_gnds inh_vdd inh_vdds) LVT_invx2_PB4_AFBB
    U82 (n82 n75 inh_gnd inh_gnds inh_vdd inh_vdds) LVT_invx2_PB4_AFBB
    U29 (A\<6\> n29 inh_gnd inh_gnds inh_vdd inh_vdds) LVT_invx2_PB4_AFBB
    U80 (n81 n73 inh_gnd inh_gnds inh_vdd inh_vdds) LVT_invx2_PB4_AFBB
    U22 (B\<6\> n22 inh_gnd inh_gnds inh_vdd inh_vdds) LVT_invx2_PB4_AFBB
    U76 (n79 n69 inh_gnd inh_gnds inh_vdd inh_vdds) LVT_invx2_PB4_AFBB
    U84 (n83 n76 inh_gnd inh_gnds inh_vdd inh_vdds) LVT_invx2_PB4_AFBB
    U28 (A\<6\> n28 inh_gnd inh_gnds inh_vdd inh_vdds) LVT_invx2_PB4_AFBB
    U78 (n80 n71 inh_gnd inh_gnds inh_vdd inh_vdds) LVT_invx2_PB4_AFBB
    U23 (B\<6\> n23 inh_gnd inh_gnds inh_vdd inh_vdds) LVT_invx2_PB4_AFBB
    U35 (n37 DIFF\<7\> inh_gnd inh_gnds inh_vdd inh_vdds) LVT_invx2_PB4_AFBB
    U60 (n59 n52 inh_gnd inh_gnds inh_vdd inh_vdds) LVT_invx2_PB4_AFBB
    U56 (n57 n50 inh_gnd inh_gnds inh_vdd inh_vdds) LVT_invx2_PB4_AFBB
    U16 (A\<7\> n16 inh_gnd inh_gnds inh_vdd inh_vdds) LVT_invx2_PB4_AFBB
    U54 (n56 n48 inh_gnd inh_gnds inh_vdd inh_vdds) LVT_invx2_PB4_AFBB
    U20 (B\<7\> n20 inh_gnd inh_gnds inh_vdd inh_vdds) LVT_invx2_PB4_AFBB
    U12 (A\<6\> n12 inh_gnd inh_gnds inh_vdd inh_vdds) LVT_invx2_PB4_AFBB
    U74 (n78 n67 inh_gnd inh_gnds inh_vdd inh_vdds) LVT_invx2_PB4_AFBB
    U13 (A\<6\> n13 inh_gnd inh_gnds inh_vdd inh_vdds) LVT_invx2_PB4_AFBB
    U50 (n54 n44 inh_gnd inh_gnds inh_vdd inh_vdds) LVT_invx2_PB4_AFBB
    U58 (n58 n51 inh_gnd inh_gnds inh_vdd inh_vdds) LVT_invx2_PB4_AFBB
    U26 (A\<7\> n26 inh_gnd inh_gnds inh_vdd inh_vdds) LVT_invx2_PB4_AFBB
    U52 (n55 n46 inh_gnd inh_gnds inh_vdd inh_vdds) LVT_invx2_PB4_AFBB
    U21 (B\<7\> n21 inh_gnd inh_gnds inh_vdd inh_vdds) LVT_invx2_PB4_AFBB
    U36 (n36 carry\<8\> inh_gnd inh_gnds inh_vdd inh_vdds) LVT_invx2_PB4_AFBB
    U48 (n53 n42 inh_gnd inh_gnds inh_vdd inh_vdds) LVT_invx2_PB4_AFBB
    U27 (A\<7\> n27 inh_gnd inh_gnds inh_vdd inh_vdds) LVT_invx2_PB4_AFBB
    U17 (A\<7\> n17 inh_gnd inh_gnds inh_vdd inh_vdds) LVT_invx2_PB4_AFBB
    U15 (A\<9\> n15 inh_gnd inh_gnds inh_vdd inh_vdds) LVT_invx2_PB4_AFBB
    U89 (n85 n87 inh_gnd inh_gnds inh_vdd inh_vdds) LVT_invx2_PB4_AFBB
    U92 (n86 n91 inh_gnd inh_gnds inh_vdd inh_vdds) LVT_invx2_PB4_AFBB
    U30 (n86 n30 inh_gnd inh_gnds inh_vdd inh_vdds) LVT_invx2_PB4_AFBB
    U88 (n85 n86 inh_gnd inh_gnds inh_vdd inh_vdds) LVT_invx2_PB4_AFBB
    U87 (carry\<9\> n85 inh_gnd inh_gnds inh_vdd inh_vdds) LVT_invx2_PB4_AFBB
    U62 (n61 carry\<7\> inh_gnd inh_gnds inh_vdd inh_vdds) LVT_invx2_PB4_AFBB
    U34 (n32 n34 inh_gnd inh_gnds inh_vdd inh_vdds) LVT_invx2_PB4_AFBB
    U63 (n33 n63 inh_gnd inh_gnds inh_vdd inh_vdds) LVT_invx2_PB4_AFBB
    U31 (n33 n31 inh_gnd inh_gnds inh_vdd inh_vdds) LVT_invx2_PB4_AFBB
    U33 (n32 n33 inh_gnd inh_gnds inh_vdd inh_vdds) LVT_invx2_PB4_AFBB
    U32 (carry\<6\> n32 inh_gnd inh_gnds inh_vdd inh_vdds) LVT_invx2_PB4_AFBB
    U37 (carry\<7\> n38 inh_gnd inh_gnds inh_vdd inh_vdds) LVT_invx2_PB4_AFBB
    U176 (n342 A\<11\> n175 inh_gnd inh_gnds inh_vdd inh_vdds) LVT_NOR2x1_PB4_AFBB
    U167 (n142 n167 n166 inh_gnd inh_gnds inh_vdd inh_vdds) LVT_NOR2x1_PB4_AFBB
    U169 (n170 n171 n157 inh_gnd inh_gnds inh_vdd inh_vdds) LVT_NOR2x1_PB4_AFBB
    U168 (B\<11\> n169 n168 inh_gnd inh_gnds inh_vdd inh_vdds) LVT_NOR2x1_PB4_AFBB
    U182 (n168 n166 n178 inh_gnd inh_gnds inh_vdd inh_vdds) LVT_NOR2x1_PB4_AFBB
    U180 (n162 n164 n177 inh_gnd inh_gnds inh_vdd inh_vdds) LVT_NOR2x1_PB4_AFBB
    U165 (B\<11\> n163 n162 inh_gnd inh_gnds inh_vdd inh_vdds) LVT_NOR2x1_PB4_AFBB
    U172 (A\<11\> n143 n173 inh_gnd inh_gnds inh_vdd inh_vdds) LVT_NOR2x1_PB4_AFBB
    U174 (n118 n143 n174 inh_gnd inh_gnds inh_vdd inh_vdds) LVT_NOR2x1_PB4_AFBB
    U166 (n158 n165 n164 inh_gnd inh_gnds inh_vdd inh_vdds) LVT_NOR2x1_PB4_AFBB
    U200 (n339 n155 n198 inh_gnd inh_gnds inh_vdd inh_vdds) LVT_NOR2x1_PB4_AFBB
    U192 (n128 n189 n188 inh_gnd inh_gnds inh_vdd inh_vdds) LVT_NOR2x1_PB4_AFBB
    U191 (B\<14\> n187 n186 inh_gnd inh_gnds inh_vdd inh_vdds) LVT_NOR2x1_PB4_AFBB
    U198 (A\<14\> n155 n197 inh_gnd inh_gnds inh_vdd inh_vdds) LVT_NOR2x1_PB4_AFBB
    U205 (n186 n188 n200 inh_gnd inh_gnds inh_vdd inh_vdds) LVT_NOR2x1_PB4_AFBB
    U195 (n194 n195 n180 inh_gnd inh_gnds inh_vdd inh_vdds) LVT_NOR2x1_PB4_AFBB
    U194 (B\<14\> n193 n192 inh_gnd inh_gnds inh_vdd inh_vdds) LVT_NOR2x1_PB4_AFBB
    U193 (n154 n191 n190 inh_gnd inh_gnds inh_vdd inh_vdds) LVT_NOR2x1_PB4_AFBB
    U202 (n139 A\<14\> n199 inh_gnd inh_gnds inh_vdd inh_vdds) LVT_NOR2x1_PB4_AFBB
    U207 (n192 n190 n201 inh_gnd inh_gnds inh_vdd inh_vdds) LVT_NOR2x1_PB4_AFBB
    U225 (n336 n153 n221 inh_gnd inh_gnds inh_vdd inh_vdds) LVT_NOR2x1_PB4_AFBB
    U217 (n126 n212 n211 inh_gnd inh_gnds inh_vdd inh_vdds) LVT_NOR2x1_PB4_AFBB
    U216 (B\<17\> n210 n209 inh_gnd inh_gnds inh_vdd inh_vdds) LVT_NOR2x1_PB4_AFBB
    U223 (A\<17\> n153 n220 inh_gnd inh_gnds inh_vdd inh_vdds) LVT_NOR2x1_PB4_AFBB
    U230 (n209 n211 n223 inh_gnd inh_gnds inh_vdd inh_vdds) LVT_NOR2x1_PB4_AFBB
    U220 (n217 n218 n203 inh_gnd inh_gnds inh_vdd inh_vdds) LVT_NOR2x1_PB4_AFBB
    U219 (B\<17\> n216 n215 inh_gnd inh_gnds inh_vdd inh_vdds) LVT_NOR2x1_PB4_AFBB
    U218 (n152 n214 n213 inh_gnd inh_gnds inh_vdd inh_vdds) LVT_NOR2x1_PB4_AFBB
    U227 (n138 A\<17\> n222 inh_gnd inh_gnds inh_vdd inh_vdds) LVT_NOR2x1_PB4_AFBB
    U232 (n215 n213 n224 inh_gnd inh_gnds inh_vdd inh_vdds) LVT_NOR2x1_PB4_AFBB
    U250 (n333 n151 n244 inh_gnd inh_gnds inh_vdd inh_vdds) LVT_NOR2x1_PB4_AFBB
    U242 (n124 n235 n234 inh_gnd inh_gnds inh_vdd inh_vdds) LVT_NOR2x1_PB4_AFBB
    U241 (B\<20\> n233 n232 inh_gnd inh_gnds inh_vdd inh_vdds) LVT_NOR2x1_PB4_AFBB
    U248 (A\<20\> n151 n243 inh_gnd inh_gnds inh_vdd inh_vdds) LVT_NOR2x1_PB4_AFBB
    U255 (n232 n234 n246 inh_gnd inh_gnds inh_vdd inh_vdds) LVT_NOR2x1_PB4_AFBB
    U245 (n240 n241 n226 inh_gnd inh_gnds inh_vdd inh_vdds) LVT_NOR2x1_PB4_AFBB
    U244 (B\<20\> n239 n238 inh_gnd inh_gnds inh_vdd inh_vdds) LVT_NOR2x1_PB4_AFBB
    U243 (n150 n237 n236 inh_gnd inh_gnds inh_vdd inh_vdds) LVT_NOR2x1_PB4_AFBB
    U252 (n137 A\<20\> n245 inh_gnd inh_gnds inh_vdd inh_vdds) LVT_NOR2x1_PB4_AFBB
    U257 (n238 n236 n247 inh_gnd inh_gnds inh_vdd inh_vdds) LVT_NOR2x1_PB4_AFBB
    U275 (n330 n149 n267 inh_gnd inh_gnds inh_vdd inh_vdds) LVT_NOR2x1_PB4_AFBB
    U267 (n122 n258 n257 inh_gnd inh_gnds inh_vdd inh_vdds) LVT_NOR2x1_PB4_AFBB
    U266 (B\<23\> n256 n255 inh_gnd inh_gnds inh_vdd inh_vdds) LVT_NOR2x1_PB4_AFBB
    U273 (A\<23\> n149 n266 inh_gnd inh_gnds inh_vdd inh_vdds) LVT_NOR2x1_PB4_AFBB
    U280 (n255 n257 n269 inh_gnd inh_gnds inh_vdd inh_vdds) LVT_NOR2x1_PB4_AFBB
    U282 (n261 n259 n270 inh_gnd inh_gnds inh_vdd inh_vdds) LVT_NOR2x1_PB4_AFBB
    U269 (B\<23\> n262 n261 inh_gnd inh_gnds inh_vdd inh_vdds) LVT_NOR2x1_PB4_AFBB
    U270 (n263 n264 n249 inh_gnd inh_gnds inh_vdd inh_vdds) LVT_NOR2x1_PB4_AFBB
    U277 (n136 A\<23\> n268 inh_gnd inh_gnds inh_vdd inh_vdds) LVT_NOR2x1_PB4_AFBB
    U268 (n148 n260 n259 inh_gnd inh_gnds inh_vdd inh_vdds) LVT_NOR2x1_PB4_AFBB
    U336 (A\<0\> n350 n318 inh_gnd inh_gnds inh_vdd inh_vdds) LVT_NOR2x1_PB4_AFBB
    U300 (n327 n147 n290 inh_gnd inh_gnds inh_vdd inh_vdds) LVT_NOR2x1_PB4_AFBB
    U292 (n120 n281 n280 inh_gnd inh_gnds inh_vdd inh_vdds) LVT_NOR2x1_PB4_AFBB
    U291 (B\<26\> n279 n278 inh_gnd inh_gnds inh_vdd inh_vdds) LVT_NOR2x1_PB4_AFBB
    U298 (A\<26\> n147 n289 inh_gnd inh_gnds inh_vdd inh_vdds) LVT_NOR2x1_PB4_AFBB
    U305 (n278 n280 n292 inh_gnd inh_gnds inh_vdd inh_vdds) LVT_NOR2x1_PB4_AFBB
    U295 (n286 n287 n272 inh_gnd inh_gnds inh_vdd inh_vdds) LVT_NOR2x1_PB4_AFBB
    U294 (B\<26\> n285 n284 inh_gnd inh_gnds inh_vdd inh_vdds) LVT_NOR2x1_PB4_AFBB
    U293 (n146 n283 n282 inh_gnd inh_gnds inh_vdd inh_vdds) LVT_NOR2x1_PB4_AFBB
    U302 (n135 A\<26\> n291 inh_gnd inh_gnds inh_vdd inh_vdds) LVT_NOR2x1_PB4_AFBB
    U307 (n284 n282 n293 inh_gnd inh_gnds inh_vdd inh_vdds) LVT_NOR2x1_PB4_AFBB
    U326 (n145 n324 n314 inh_gnd inh_gnds inh_vdd inh_vdds) LVT_NOR2x1_PB4_AFBB
    U318 (n131 n305 n304 inh_gnd inh_gnds inh_vdd inh_vdds) LVT_NOR2x1_PB4_AFBB
    U317 (B\<29\> n303 n302 inh_gnd inh_gnds inh_vdd inh_vdds) LVT_NOR2x1_PB4_AFBB
    U324 (A\<29\> n145 n313 inh_gnd inh_gnds inh_vdd inh_vdds) LVT_NOR2x1_PB4_AFBB
    U331 (n302 n304 n316 inh_gnd inh_gnds inh_vdd inh_vdds) LVT_NOR2x1_PB4_AFBB
    U321 (n310 n311 n295 inh_gnd inh_gnds inh_vdd inh_vdds) LVT_NOR2x1_PB4_AFBB
    U320 (B\<29\> n309 n308 inh_gnd inh_gnds inh_vdd inh_vdds) LVT_NOR2x1_PB4_AFBB
    U319 (n296 n307 n306 inh_gnd inh_gnds inh_vdd inh_vdds) LVT_NOR2x1_PB4_AFBB
    U328 (n134 A\<29\> n315 inh_gnd inh_gnds inh_vdd inh_vdds) LVT_NOR2x1_PB4_AFBB
    U333 (n308 n306 n317 inh_gnd inh_gnds inh_vdd inh_vdds) LVT_NOR2x1_PB4_AFBB
    U314 (n296 B\<29\> n299 inh_gnd inh_gnds inh_vdd inh_vdds) LVT_NOR2x1_PB4_AFBB
    U322 (n299 n132 n312 inh_gnd inh_gnds inh_vdd inh_vdds) LVT_NOR2x1_PB4_AFBB
    U315 (n297 B\<29\> n300 inh_gnd inh_gnds inh_vdd inh_vdds) LVT_NOR2x1_PB4_AFBB
    U316 (n300 n301 n294 inh_gnd inh_gnds inh_vdd inh_vdds) LVT_NOR2x1_PB4_AFBB
    U338 (A\<0\> B\<0\> n320 inh_gnd inh_gnds inh_vdd inh_vdds) LVT_NOR2x1_PB4_AFBB
    U340 (n320 n321 DIFF\<0\> inh_gnd inh_gnds inh_vdd inh_vdds) LVT_NOR2x1_PB4_AFBB
    U339 (n133 n319 n321 inh_gnd inh_gnds inh_vdd inh_vdds) LVT_NOR2x1_PB4_AFBB
    U288 (n146 B\<26\> n275 inh_gnd inh_gnds inh_vdd inh_vdds) LVT_NOR2x1_PB4_AFBB
    U296 (n275 n117 n288 inh_gnd inh_gnds inh_vdd inh_vdds) LVT_NOR2x1_PB4_AFBB
    U289 (n273 B\<26\> n276 inh_gnd inh_gnds inh_vdd inh_vdds) LVT_NOR2x1_PB4_AFBB
    U290 (n276 n277 n271 inh_gnd inh_gnds inh_vdd inh_vdds) LVT_NOR2x1_PB4_AFBB
    U264 (n250 B\<23\> n253 inh_gnd inh_gnds inh_vdd inh_vdds) LVT_NOR2x1_PB4_AFBB
    U265 (n253 n254 n248 inh_gnd inh_gnds inh_vdd inh_vdds) LVT_NOR2x1_PB4_AFBB
    U263 (n148 B\<23\> n252 inh_gnd inh_gnds inh_vdd inh_vdds) LVT_NOR2x1_PB4_AFBB
    U262 (n148 n121 n251 inh_gnd inh_gnds inh_vdd inh_vdds) LVT_NOR2x1_PB4_AFBB
    U271 (n252 n116 n265 inh_gnd inh_gnds inh_vdd inh_vdds) LVT_NOR2x1_PB4_AFBB
    U239 (n227 B\<20\> n230 inh_gnd inh_gnds inh_vdd inh_vdds) LVT_NOR2x1_PB4_AFBB
    U240 (n230 n231 n225 inh_gnd inh_gnds inh_vdd inh_vdds) LVT_NOR2x1_PB4_AFBB
    U238 (n150 B\<20\> n229 inh_gnd inh_gnds inh_vdd inh_vdds) LVT_NOR2x1_PB4_AFBB
    U246 (n229 n115 n242 inh_gnd inh_gnds inh_vdd inh_vdds) LVT_NOR2x1_PB4_AFBB
    U237 (n150 n123 n228 inh_gnd inh_gnds inh_vdd inh_vdds) LVT_NOR2x1_PB4_AFBB
    U214 (n204 B\<17\> n207 inh_gnd inh_gnds inh_vdd inh_vdds) LVT_NOR2x1_PB4_AFBB
    U215 (n207 n208 n202 inh_gnd inh_gnds inh_vdd inh_vdds) LVT_NOR2x1_PB4_AFBB
    U213 (n152 B\<17\> n206 inh_gnd inh_gnds inh_vdd inh_vdds) LVT_NOR2x1_PB4_AFBB
    U221 (n206 n114 n219 inh_gnd inh_gnds inh_vdd inh_vdds) LVT_NOR2x1_PB4_AFBB
    U212 (n152 n125 n205 inh_gnd inh_gnds inh_vdd inh_vdds) LVT_NOR2x1_PB4_AFBB
    U189 (n181 B\<14\> n184 inh_gnd inh_gnds inh_vdd inh_vdds) LVT_NOR2x1_PB4_AFBB
    U190 (n184 n185 n179 inh_gnd inh_gnds inh_vdd inh_vdds) LVT_NOR2x1_PB4_AFBB
    U188 (n154 B\<14\> n183 inh_gnd inh_gnds inh_vdd inh_vdds) LVT_NOR2x1_PB4_AFBB
    U196 (n183 n113 n196 inh_gnd inh_gnds inh_vdd inh_vdds) LVT_NOR2x1_PB4_AFBB
    U187 (n154 n127 n182 inh_gnd inh_gnds inh_vdd inh_vdds) LVT_NOR2x1_PB4_AFBB
    U163 (n140 B\<11\> n160 inh_gnd inh_gnds inh_vdd inh_vdds) LVT_NOR2x1_PB4_AFBB
    U164 (n160 n161 n156 inh_gnd inh_gnds inh_vdd inh_vdds) LVT_NOR2x1_PB4_AFBB
    U162 (n142 B\<11\> n159 inh_gnd inh_gnds inh_vdd inh_vdds) LVT_NOR2x1_PB4_AFBB
    U170 (n159 n129 n172 inh_gnd inh_gnds inh_vdd inh_vdds) LVT_NOR2x1_PB4_AFBB
    U178 (n142 n141 n176 inh_gnd inh_gnds inh_vdd inh_vdds) LVT_NOR2x1_PB4_AFBB
    U95 (n14 B\<9\> n94 inh_gnd inh_gnds inh_vdd inh_vdds) LVT_NOR2x1_PB4_AFBB
    U96 (n94 n95 n89 inh_gnd inh_gnds inh_vdd inh_vdds) LVT_NOR2x1_PB4_AFBB
    U313 (n144 n130 n298 inh_gnd inh_gnds inh_vdd inh_vdds) LVT_NOR2x1_PB4_AFBB
    U287 (n146 n119 n274 inh_gnd inh_gnds inh_vdd inh_vdds) LVT_NOR2x1_PB4_AFBB
    U101 (n104 n105 n90 inh_gnd inh_gnds inh_vdd inh_vdds) LVT_NOR2x1_PB4_AFBB
    U100 (B\<9\> n103 n102 inh_gnd inh_gnds inh_vdd inh_vdds) LVT_NOR2x1_PB4_AFBB
    U110 (n25 n30 n110 inh_gnd inh_gnds inh_vdd inh_vdds) LVT_NOR2x1_PB4_AFBB
    U99 (n91 n101 n100 inh_gnd inh_gnds inh_vdd inh_vdds) LVT_NOR2x1_PB4_AFBB
    U108 (n18 A\<9\> n109 inh_gnd inh_gnds inh_vdd inh_vdds) LVT_NOR2x1_PB4_AFBB
    U114 (n100 n102 n112 inh_gnd inh_gnds inh_vdd inh_vdds) LVT_NOR2x1_PB4_AFBB
    U112 (n96 n98 n111 inh_gnd inh_gnds inh_vdd inh_vdds) LVT_NOR2x1_PB4_AFBB
    U97 (B\<9\> n97 n96 inh_gnd inh_gnds inh_vdd inh_vdds) LVT_NOR2x1_PB4_AFBB
    U104 (A\<9\> n87 n107 inh_gnd inh_gnds inh_vdd inh_vdds) LVT_NOR2x1_PB4_AFBB
    U106 (n19 n87 n108 inh_gnd inh_gnds inh_vdd inh_vdds) LVT_NOR2x1_PB4_AFBB
    U98 (n24 n99 n98 inh_gnd inh_gnds inh_vdd inh_vdds) LVT_NOR2x1_PB4_AFBB
    U72 (n76 n77 n62 inh_gnd inh_gnds inh_vdd inh_vdds) LVT_NOR2x1_PB4_AFBB
    U71 (B\<6\> n75 n74 inh_gnd inh_gnds inh_vdd inh_vdds) LVT_NOR2x1_PB4_AFBB
    U81 (n29 n31 n82 inh_gnd inh_gnds inh_vdd inh_vdds) LVT_NOR2x1_PB4_AFBB
    U70 (n63 n73 n72 inh_gnd inh_gnds inh_vdd inh_vdds) LVT_NOR2x1_PB4_AFBB
    U79 (n22 A\<6\> n81 inh_gnd inh_gnds inh_vdd inh_vdds) LVT_NOR2x1_PB4_AFBB
    U85 (n72 n74 n84 inh_gnd inh_gnds inh_vdd inh_vdds) LVT_NOR2x1_PB4_AFBB
    U83 (n68 n70 n83 inh_gnd inh_gnds inh_vdd inh_vdds) LVT_NOR2x1_PB4_AFBB
    U68 (B\<6\> n69 n68 inh_gnd inh_gnds inh_vdd inh_vdds) LVT_NOR2x1_PB4_AFBB
    U75 (A\<6\> n34 n79 inh_gnd inh_gnds inh_vdd inh_vdds) LVT_NOR2x1_PB4_AFBB
    U77 (n23 n34 n80 inh_gnd inh_gnds inh_vdd inh_vdds) LVT_NOR2x1_PB4_AFBB
    U69 (n28 n71 n70 inh_gnd inh_gnds inh_vdd inh_vdds) LVT_NOR2x1_PB4_AFBB
    U46 (n51 n52 n37 inh_gnd inh_gnds inh_vdd inh_vdds) LVT_NOR2x1_PB4_AFBB
    U45 (B\<7\> n50 n49 inh_gnd inh_gnds inh_vdd inh_vdds) LVT_NOR2x1_PB4_AFBB
    U55 (n38 n16 n57 inh_gnd inh_gnds inh_vdd inh_vdds) LVT_NOR2x1_PB4_AFBB
    U44 (n61 n48 n47 inh_gnd inh_gnds inh_vdd inh_vdds) LVT_NOR2x1_PB4_AFBB
    U53 (n20 A\<7\> n56 inh_gnd inh_gnds inh_vdd inh_vdds) LVT_NOR2x1_PB4_AFBB
    U59 (n47 n49 n59 inh_gnd inh_gnds inh_vdd inh_vdds) LVT_NOR2x1_PB4_AFBB
    U67 (n66 n67 n61 inh_gnd inh_gnds inh_vdd inh_vdds) LVT_NOR2x1_PB4_AFBB
    U66 (n12 B\<6\> n66 inh_gnd inh_gnds inh_vdd inh_vdds) LVT_NOR2x1_PB4_AFBB
    U65 (n63 B\<6\> n65 inh_gnd inh_gnds inh_vdd inh_vdds) LVT_NOR2x1_PB4_AFBB
    U64 (n31 n13 n64 inh_gnd inh_gnds inh_vdd inh_vdds) LVT_NOR2x1_PB4_AFBB
    U73 (n64 n65 n78 inh_gnd inh_gnds inh_vdd inh_vdds) LVT_NOR2x1_PB4_AFBB
    U57 (n43 n45 n58 inh_gnd inh_gnds inh_vdd inh_vdds) LVT_NOR2x1_PB4_AFBB
    U42 (B\<7\> n44 n43 inh_gnd inh_gnds inh_vdd inh_vdds) LVT_NOR2x1_PB4_AFBB
    U49 (A\<7\> carry\<7\> n54 inh_gnd inh_gnds inh_vdd inh_vdds) LVT_NOR2x1_PB4_AFBB
    U51 (n21 carry\<7\> n55 inh_gnd inh_gnds inh_vdd inh_vdds) LVT_NOR2x1_PB4_AFBB
    U43 (n26 n46 n45 inh_gnd inh_gnds inh_vdd inh_vdds) LVT_NOR2x1_PB4_AFBB
    U40 (n27 B\<7\> n41 inh_gnd inh_gnds inh_vdd inh_vdds) LVT_NOR2x1_PB4_AFBB
    U41 (n41 n42 n36 inh_gnd inh_gnds inh_vdd inh_vdds) LVT_NOR2x1_PB4_AFBB
    U39 (n38 B\<7\> n40 inh_gnd inh_gnds inh_vdd inh_vdds) LVT_NOR2x1_PB4_AFBB
    U38 (n38 n17 n39 inh_gnd inh_gnds inh_vdd inh_vdds) LVT_NOR2x1_PB4_AFBB
    U47 (n39 n40 n53 inh_gnd inh_gnds inh_vdd inh_vdds) LVT_NOR2x1_PB4_AFBB
    U94 (n91 B\<9\> n93 inh_gnd inh_gnds inh_vdd inh_vdds) LVT_NOR2x1_PB4_AFBB
    U102 (n92 n93 n106 inh_gnd inh_gnds inh_vdd inh_vdds) LVT_NOR2x1_PB4_AFBB
    U93 (n30 n15 n92 inh_gnd inh_gnds inh_vdd inh_vdds) LVT_NOR2x1_PB4_AFBB
    U2_2 (A\<2\> n348 n1 carry\<3\> DIFF\<2\> inh_gnd inh_gnds inh_vdd inh_vdds) LVT_FAx1_PB4_AFBB
    U2_3 (A\<3\> n347 n10 carry\<4\> DIFF\<3\> inh_gnd inh_gnds inh_vdd inh_vdds) LVT_FAx1_PB4_AFBB
    U2_4 (A\<4\> n346 n11 carry\<5\> DIFF\<4\> inh_gnd inh_gnds inh_vdd inh_vdds) LVT_FAx1_PB4_AFBB
    U2_5 (A\<5\> n345 n9 carry\<6\> DIFF\<5\> inh_gnd inh_gnds inh_vdd inh_vdds) LVT_FAx1_PB4_AFBB
    U2_13 (A\<13\> n340 n5 carry\<14\> DIFF\<13\> inh_gnd inh_gnds inh_vdd inh_vdds) LVT_FAx1_PB4_AFBB
    U2_16 (A\<16\> n337 n2 carry\<17\> DIFF\<16\> inh_gnd inh_gnds inh_vdd inh_vdds) LVT_FAx1_PB4_AFBB
    U2_19 (A\<19\> n334 n3 carry\<20\> DIFF\<19\> inh_gnd inh_gnds inh_vdd inh_vdds) LVT_FAx1_PB4_AFBB
    U2_22 (A\<22\> n331 n6 carry\<23\> DIFF\<22\> inh_gnd inh_gnds inh_vdd inh_vdds) LVT_FAx1_PB4_AFBB
    U2_1 (A\<1\> n349 carry\<1\> carry\<2\> DIFF\<1\> inh_gnd inh_gnds inh_vdd inh_vdds) LVT_FAx1_PB4_AFBB
    U2_8 (A\<8\> n344 carry\<8\> carry\<9\> DIFF\<8\> inh_gnd inh_gnds inh_vdd inh_vdds) LVT_FAx1_PB4_AFBB
    U2_10 (A\<10\> n343 carry\<10\> carry\<11\> DIFF\<10\> inh_gnd inh_gnds inh_vdd inh_vdds) LVT_FAx1_PB4_AFBB
    U2_12 (A\<12\> n341 carry\<12\> carry\<13\> DIFF\<12\> inh_gnd inh_gnds inh_vdd inh_vdds) LVT_FAx1_PB4_AFBB
    U2_15 (A\<15\> n338 carry\<15\> carry\<16\> DIFF\<15\> inh_gnd inh_gnds inh_vdd inh_vdds) LVT_FAx1_PB4_AFBB
    U2_18 (A\<18\> n335 carry\<18\> carry\<19\> DIFF\<18\> inh_gnd inh_gnds inh_vdd inh_vdds) LVT_FAx1_PB4_AFBB
    U2_21 (A\<21\> n332 carry\<21\> carry\<22\> DIFF\<21\> inh_gnd inh_gnds inh_vdd inh_vdds) LVT_FAx1_PB4_AFBB
    U2_25 (A\<25\> n328 n7 carry\<26\> DIFF\<25\> inh_gnd inh_gnds inh_vdd inh_vdds) LVT_FAx1_PB4_AFBB
    U2_28 (A\<28\> n325 n4 carry\<29\> DIFF\<28\> inh_gnd inh_gnds inh_vdd inh_vdds) LVT_FAx1_PB4_AFBB
    U2_31 (A\<31\> n322 n8 NeTt_1062 DIFF\<31\> inh_gnd inh_gnds inh_vdd inh_vdds) LVT_FAx1_PB4_AFBB
    U2_24 (A\<24\> n329 carry\<24\> carry\<25\> DIFF\<24\> inh_gnd inh_gnds inh_vdd inh_vdds) LVT_FAx1_PB4_AFBB
    U2_27 (A\<27\> n326 carry\<27\> carry\<28\> DIFF\<27\> inh_gnd inh_gnds inh_vdd inh_vdds) LVT_FAx1_PB4_AFBB
    U2_30 (A\<30\> n323 carry\<30\> carry\<31\> DIFF\<30\> inh_gnd inh_gnds inh_vdd inh_vdds) LVT_FAx1_PB4_AFBB
    U1 (carry\<2\> n1 inh_gnd inh_gnds inh_vdd inh_vdds) LVT_BUFx1_PB4_AFBB
    U10 (carry\<3\> n10 inh_gnd inh_gnds inh_vdd inh_vdds) LVT_BUFx1_PB4_AFBB
    U11 (carry\<4\> n11 inh_gnd inh_gnds inh_vdd inh_vdds) LVT_BUFx1_PB4_AFBB
    U9 (carry\<5\> n9 inh_gnd inh_gnds inh_vdd inh_vdds) LVT_BUFx1_PB4_AFBB
    U5 (carry\<13\> n5 inh_gnd inh_gnds inh_vdd inh_vdds) LVT_BUFx1_PB4_AFBB
    U2 (carry\<16\> n2 inh_gnd inh_gnds inh_vdd inh_vdds) LVT_BUFx1_PB4_AFBB
    U3 (carry\<19\> n3 inh_gnd inh_gnds inh_vdd inh_vdds) LVT_BUFx1_PB4_AFBB
    U6 (carry\<22\> n6 inh_gnd inh_gnds inh_vdd inh_vdds) LVT_BUFx1_PB4_AFBB
    U7 (carry\<25\> n7 inh_gnd inh_gnds inh_vdd inh_vdds) LVT_BUFx1_PB4_AFBB
    U4 (carry\<28\> n4 inh_gnd inh_gnds inh_vdd inh_vdds) LVT_BUFx1_PB4_AFBB
    U8 (carry\<31\> n8 inh_gnd inh_gnds inh_vdd inh_vdds) LVT_BUFx1_PB4_AFBB
ends alu_subtractor_DW01_sub_0

// power_gating_fine/alu_subtractor/schematic
subckt alu_subtractor pwr_en A\<31\> A\<30\> A\<29\> A\<28\> A\<27\> A\<26\> A\<25\> A\<24\> A\<23\> A\<22\> A\<21\> A\<20\> A\<19\> A\<18\> A\<17\> A\<16\> A\<15\> A\<14\> A\<13\> A\<12\> A\<11\> A\<10\> A\<9\> A\<8\> A\<7\> A\<6\> A\<5\> A\<4\> A\<3\> A\<2\> A\<1\> A\<0\> B\<31\> B\<30\> B\<29\> B\<28\> B\<27\> B\<26\> B\<25\> B\<24\> B\<23\> B\<22\> B\<21\> B\<20\> B\<19\> B\<18\> B\<17\> B\<16\> B\<15\> B\<14\> B\<13\> B\<12\> B\<11\> B\<10\> B\<9\> B\<8\> B\<7\> B\<6\> B\<5\> B\<4\> B\<3\> B\<2\> B\<1\> B\<0\> C\<31\> C\<30\> C\<29\> C\<28\> C\<27\> C\<26\> C\<25\> C\<24\> C\<23\> C\<22\> C\<21\> C\<20\> C\<19\> C\<18\> C\<17\> C\<16\> C\<15\> C\<14\> C\<13\> C\<12\> C\<11\> C\<10\> C\<9\> C\<8\> C\<7\> C\<6\> C\<5\> C\<4\> C\<3\> C\<2\> C\<1\> C\<0\> inh_gnd inh_gnds vdd_in inh_vdds
    U160 (pwr_en pwr_en_bar inh_gnd inh_gnds vdd_in inh_vdds) LVT_invx2_PB4_AFBB
    alu_subtractor_pwr_pmos (inh_vdd pwr_en_bar vdd_in inh_vdds) lvtpfet w=8000n l=30.00n nf=(2)*(1) ngcon=1 nsig_delvto_uo1=0 nsig_delvto_uo2=0 soa=1 swshe=0 swacc=0 swrg=0 swrsub=0 mismatch=1 m=1
    sub_21 (A\<31\> A\<30\> A\<29\> A\<28\> A\<27\> A\<26\> A\<25\> A\<24\> A\<23\> A\<22\> A\<21\> A\<20\> A\<19\> A\<18\> A\<17\> A\<16\> A\<15\> A\<14\> A\<13\> A\<12\> A\<11\> A\<10\> A\<9\> A\<8\> A\<7\> A\<6\> A\<5\> A\<4\> A\<3\> A\<2\> A\<1\> A\<0\> B\<31\> B\<30\> B\<29\> B\<28\> B\<27\> B\<26\> B\<25\> B\<24\> B\<23\> B\<22\> B\<21\> B\<20\> B\<19\> B\<18\> B\<17\> B\<16\> B\<15\> B\<14\> B\<13\> B\<12\> B\<11\> B\<10\> B\<9\> B\<8\> B\<7\> B\<6\> B\<5\> B\<4\> B\<3\> B\<2\> B\<1\> B\<0\> GND! subtraction\<31\> subtraction\<30\> subtraction\<29\> subtraction\<28\> subtraction\<27\> subtraction\<26\> subtraction\<25\> subtraction\<24\> subtraction\<23\> subtraction\<22\> subtraction\<21\> subtraction\<20\> subtraction\<19\> subtraction\<18\> subtraction\<17\> subtraction\<16\> subtraction\<15\> subtraction\<14\> subtraction\<13\> subtraction\<12\> subtraction\<11\> subtraction\<10\> subtraction\<9\> subtraction\<8\> subtraction\<7\> subtraction\<6\> subtraction\<5\> subtraction\<4\> subtraction\<3\> subtraction\<2\> subtraction\<1\> subtraction\<0\> NeTt_135 inh_gnd inh_gnds inh_vdd inh_vdds) alu_subtractor_DW01_sub_0
    Thru31 (subtraction\<0\> C\<0\>) iprobe
    Thru30 (subtraction\<1\> C\<1\>) iprobe
    Thru29 (subtraction\<2\> C\<2\>) iprobe
    Thru28 (subtraction\<3\> C\<3\>) iprobe
    Thru27 (subtraction\<4\> C\<4\>) iprobe
    Thru26 (subtraction\<5\> C\<5\>) iprobe
    Thru25 (subtraction\<6\> C\<6\>) iprobe
    Thru24 (subtraction\<7\> C\<7\>) iprobe
    Thru23 (subtraction\<8\> C\<8\>) iprobe
    Thru22 (subtraction\<9\> C\<9\>) iprobe
    Thru21 (subtraction\<10\> C\<10\>) iprobe
    Thru20 (subtraction\<11\> C\<11\>) iprobe
    Thru19 (subtraction\<12\> C\<12\>) iprobe
    Thru18 (subtraction\<13\> C\<13\>) iprobe
    Thru17 (subtraction\<14\> C\<14\>) iprobe
    Thru16 (subtraction\<15\> C\<15\>) iprobe
    Thru15 (subtraction\<16\> C\<16\>) iprobe
    Thru14 (subtraction\<17\> C\<17\>) iprobe
    Thru13 (subtraction\<18\> C\<18\>) iprobe
    Thru12 (subtraction\<19\> C\<19\>) iprobe
    Thru11 (subtraction\<20\> C\<20\>) iprobe
    Thru10 (subtraction\<21\> C\<21\>) iprobe
    Thru9 (subtraction\<22\> C\<22\>) iprobe
    Thru8 (subtraction\<23\> C\<23\>) iprobe
    Thru7 (subtraction\<24\> C\<24\>) iprobe
    Thru6 (subtraction\<25\> C\<25\>) iprobe
    Thru5 (subtraction\<26\> C\<26\>) iprobe
    Thru4 (subtraction\<27\> C\<27\>) iprobe
    Thru3 (subtraction\<28\> C\<28\>) iprobe
    Thru2 (subtraction\<29\> C\<29\>) iprobe
    Thru1 (subtraction\<30\> C\<30\>) iprobe
    Thru0 (subtraction\<31\> C\<31\>) iprobe
ends alu_subtractor

// power_gating_fine/alu_and/schematic
subckt alu_and pwr_en A\<31\> A\<30\> A\<29\> A\<28\> A\<27\> A\<26\> A\<25\> A\<24\> A\<23\> A\<22\> A\<21\> A\<20\> A\<19\> A\<18\> A\<17\> A\<16\> A\<15\> A\<14\> A\<13\> A\<12\> A\<11\> A\<10\> A\<9\> A\<8\> A\<7\> A\<6\> A\<5\> A\<4\> A\<3\> A\<2\> A\<1\> A\<0\> B\<31\> B\<30\> B\<29\> B\<28\> B\<27\> B\<26\> B\<25\> B\<24\> B\<23\> B\<22\> B\<21\> B\<20\> B\<19\> B\<18\> B\<17\> B\<16\> B\<15\> B\<14\> B\<13\> B\<12\> B\<11\> B\<10\> B\<9\> B\<8\> B\<7\> B\<6\> B\<5\> B\<4\> B\<3\> B\<2\> B\<1\> B\<0\> C\<31\> C\<30\> C\<29\> C\<28\> C\<27\> C\<26\> C\<25\> C\<24\> C\<23\> C\<22\> C\<21\> C\<20\> C\<19\> C\<18\> C\<17\> C\<16\> C\<15\> C\<14\> C\<13\> C\<12\> C\<11\> C\<10\> C\<9\> C\<8\> C\<7\> C\<6\> C\<5\> C\<4\> C\<3\> C\<2\> C\<1\> C\<0\> inh_gnd inh_gnds vdd_in inh_vdds
    UG160 (pwr_en pwr_en_bar inh_gnd inh_gnds vdd_in inh_vdds) LVT_invx2_PB4_AFBB
    alu_and_pwr_pmos (inh_vdd pwr_en_bar vdd_in inh_vdds) lvtpfet w=8000n l=30.00n nf=(2)*(1) ngcon=1 nsig_delvto_uo1=0 nsig_delvto_uo2=0 soa=1 swshe=0 swacc=0 swrg=0 swrsub=0 mismatch=1 m=1
    U1 (n32 C\<0\> inh_gnd inh_gnds inh_vdd inh_vdds) LVT_invx2_PB4_AFBB
    U29 (n31 C\<1\> inh_gnd inh_gnds inh_vdd inh_vdds) LVT_invx2_PB4_AFBB
    U6 (n30 C\<2\> inh_gnd inh_gnds inh_vdd inh_vdds) LVT_invx2_PB4_AFBB
    U4 (n29 C\<3\> inh_gnd inh_gnds inh_vdd inh_vdds) LVT_invx2_PB4_AFBB
    U28 (n28 C\<4\> inh_gnd inh_gnds inh_vdd inh_vdds) LVT_invx2_PB4_AFBB
    U32 (n27 C\<5\> inh_gnd inh_gnds inh_vdd inh_vdds) LVT_invx2_PB4_AFBB
    U31 (n26 C\<6\> inh_gnd inh_gnds inh_vdd inh_vdds) LVT_invx2_PB4_AFBB
    U30 (n25 C\<7\> inh_gnd inh_gnds inh_vdd inh_vdds) LVT_invx2_PB4_AFBB
    U27 (n24 C\<8\> inh_gnd inh_gnds inh_vdd inh_vdds) LVT_invx2_PB4_AFBB
    U26 (n23 C\<9\> inh_gnd inh_gnds inh_vdd inh_vdds) LVT_invx2_PB4_AFBB
    U25 (n22 C\<10\> inh_gnd inh_gnds inh_vdd inh_vdds) LVT_invx2_PB4_AFBB
    U24 (n21 C\<11\> inh_gnd inh_gnds inh_vdd inh_vdds) LVT_invx2_PB4_AFBB
    U23 (n20 C\<12\> inh_gnd inh_gnds inh_vdd inh_vdds) LVT_invx2_PB4_AFBB
    U22 (n19 C\<13\> inh_gnd inh_gnds inh_vdd inh_vdds) LVT_invx2_PB4_AFBB
    U21 (n18 C\<14\> inh_gnd inh_gnds inh_vdd inh_vdds) LVT_invx2_PB4_AFBB
    U20 (n17 C\<15\> inh_gnd inh_gnds inh_vdd inh_vdds) LVT_invx2_PB4_AFBB
    U5 (n16 C\<16\> inh_gnd inh_gnds inh_vdd inh_vdds) LVT_invx2_PB4_AFBB
    U3 (n15 C\<17\> inh_gnd inh_gnds inh_vdd inh_vdds) LVT_invx2_PB4_AFBB
    U2 (n14 C\<18\> inh_gnd inh_gnds inh_vdd inh_vdds) LVT_invx2_PB4_AFBB
    U19 (n13 C\<19\> inh_gnd inh_gnds inh_vdd inh_vdds) LVT_invx2_PB4_AFBB
    U18 (n12 C\<20\> inh_gnd inh_gnds inh_vdd inh_vdds) LVT_invx2_PB4_AFBB
    U17 (n11 C\<21\> inh_gnd inh_gnds inh_vdd inh_vdds) LVT_invx2_PB4_AFBB
    U16 (n10 C\<22\> inh_gnd inh_gnds inh_vdd inh_vdds) LVT_invx2_PB4_AFBB
    U15 (n9 C\<23\> inh_gnd inh_gnds inh_vdd inh_vdds) LVT_invx2_PB4_AFBB
    U14 (n8 C\<24\> inh_gnd inh_gnds inh_vdd inh_vdds) LVT_invx2_PB4_AFBB
    U13 (n7 C\<25\> inh_gnd inh_gnds inh_vdd inh_vdds) LVT_invx2_PB4_AFBB
    U12 (n6 C\<26\> inh_gnd inh_gnds inh_vdd inh_vdds) LVT_invx2_PB4_AFBB
    U11 (n5 C\<27\> inh_gnd inh_gnds inh_vdd inh_vdds) LVT_invx2_PB4_AFBB
    U10 (n4 C\<28\> inh_gnd inh_gnds inh_vdd inh_vdds) LVT_invx2_PB4_AFBB
    U9 (n3 C\<29\> inh_gnd inh_gnds inh_vdd inh_vdds) LVT_invx2_PB4_AFBB
    U8 (n2 C\<30\> inh_gnd inh_gnds inh_vdd inh_vdds) LVT_invx2_PB4_AFBB
    U7 (n1 C\<31\> inh_gnd inh_gnds inh_vdd inh_vdds) LVT_invx2_PB4_AFBB
    U64 (B\<0\> A\<0\> n32 inh_gnd inh_gnds inh_vdd inh_vdds) LVT_NADN2x1_PB4_AFBB
    U63 (B\<1\> A\<1\> n31 inh_gnd inh_gnds inh_vdd inh_vdds) LVT_NADN2x1_PB4_AFBB
    U62 (B\<2\> A\<2\> n30 inh_gnd inh_gnds inh_vdd inh_vdds) LVT_NADN2x1_PB4_AFBB
    U61 (B\<3\> A\<3\> n29 inh_gnd inh_gnds inh_vdd inh_vdds) LVT_NADN2x1_PB4_AFBB
    U60 (B\<4\> A\<4\> n28 inh_gnd inh_gnds inh_vdd inh_vdds) LVT_NADN2x1_PB4_AFBB
    U59 (B\<5\> A\<5\> n27 inh_gnd inh_gnds inh_vdd inh_vdds) LVT_NADN2x1_PB4_AFBB
    U58 (B\<6\> A\<6\> n26 inh_gnd inh_gnds inh_vdd inh_vdds) LVT_NADN2x1_PB4_AFBB
    U57 (B\<7\> A\<7\> n25 inh_gnd inh_gnds inh_vdd inh_vdds) LVT_NADN2x1_PB4_AFBB
    U56 (B\<8\> A\<8\> n24 inh_gnd inh_gnds inh_vdd inh_vdds) LVT_NADN2x1_PB4_AFBB
    U55 (B\<9\> A\<9\> n23 inh_gnd inh_gnds inh_vdd inh_vdds) LVT_NADN2x1_PB4_AFBB
    U54 (B\<10\> A\<10\> n22 inh_gnd inh_gnds inh_vdd inh_vdds) LVT_NADN2x1_PB4_AFBB
    U53 (B\<11\> A\<11\> n21 inh_gnd inh_gnds inh_vdd inh_vdds) LVT_NADN2x1_PB4_AFBB
    U52 (B\<12\> A\<12\> n20 inh_gnd inh_gnds inh_vdd inh_vdds) LVT_NADN2x1_PB4_AFBB
    U51 (B\<13\> A\<13\> n19 inh_gnd inh_gnds inh_vdd inh_vdds) LVT_NADN2x1_PB4_AFBB
    U50 (B\<14\> A\<14\> n18 inh_gnd inh_gnds inh_vdd inh_vdds) LVT_NADN2x1_PB4_AFBB
    U49 (B\<15\> A\<15\> n17 inh_gnd inh_gnds inh_vdd inh_vdds) LVT_NADN2x1_PB4_AFBB
    U48 (B\<16\> A\<16\> n16 inh_gnd inh_gnds inh_vdd inh_vdds) LVT_NADN2x1_PB4_AFBB
    U47 (B\<17\> A\<17\> n15 inh_gnd inh_gnds inh_vdd inh_vdds) LVT_NADN2x1_PB4_AFBB
    U46 (B\<18\> A\<18\> n14 inh_gnd inh_gnds inh_vdd inh_vdds) LVT_NADN2x1_PB4_AFBB
    U45 (B\<19\> A\<19\> n13 inh_gnd inh_gnds inh_vdd inh_vdds) LVT_NADN2x1_PB4_AFBB
    U44 (B\<20\> A\<20\> n12 inh_gnd inh_gnds inh_vdd inh_vdds) LVT_NADN2x1_PB4_AFBB
    U43 (B\<21\> A\<21\> n11 inh_gnd inh_gnds inh_vdd inh_vdds) LVT_NADN2x1_PB4_AFBB
    U42 (B\<22\> A\<22\> n10 inh_gnd inh_gnds inh_vdd inh_vdds) LVT_NADN2x1_PB4_AFBB
    U41 (B\<23\> A\<23\> n9 inh_gnd inh_gnds inh_vdd inh_vdds) LVT_NADN2x1_PB4_AFBB
    U40 (B\<24\> A\<24\> n8 inh_gnd inh_gnds inh_vdd inh_vdds) LVT_NADN2x1_PB4_AFBB
    U39 (B\<25\> A\<25\> n7 inh_gnd inh_gnds inh_vdd inh_vdds) LVT_NADN2x1_PB4_AFBB
    U38 (B\<26\> A\<26\> n6 inh_gnd inh_gnds inh_vdd inh_vdds) LVT_NADN2x1_PB4_AFBB
    U37 (B\<27\> A\<27\> n5 inh_gnd inh_gnds inh_vdd inh_vdds) LVT_NADN2x1_PB4_AFBB
    U36 (B\<28\> A\<28\> n4 inh_gnd inh_gnds inh_vdd inh_vdds) LVT_NADN2x1_PB4_AFBB
    U35 (B\<29\> A\<29\> n3 inh_gnd inh_gnds inh_vdd inh_vdds) LVT_NADN2x1_PB4_AFBB
    U34 (B\<30\> A\<30\> n2 inh_gnd inh_gnds inh_vdd inh_vdds) LVT_NADN2x1_PB4_AFBB
    U33 (B\<31\> A\<31\> n1 inh_gnd inh_gnds inh_vdd inh_vdds) LVT_NADN2x1_PB4_AFBB
ends alu_and

// power_gating_fine/alu_or/schematic
subckt alu_or pwr_en A\<31\> A\<30\> A\<29\> A\<28\> A\<27\> A\<26\> A\<25\> A\<24\> A\<23\> A\<22\> A\<21\> A\<20\> A\<19\> A\<18\> A\<17\> A\<16\> A\<15\> A\<14\> A\<13\> A\<12\> A\<11\> A\<10\> A\<9\> A\<8\> A\<7\> A\<6\> A\<5\> A\<4\> A\<3\> A\<2\> A\<1\> A\<0\> B\<31\> B\<30\> B\<29\> B\<28\> B\<27\> B\<26\> B\<25\> B\<24\> B\<23\> B\<22\> B\<21\> B\<20\> B\<19\> B\<18\> B\<17\> B\<16\> B\<15\> B\<14\> B\<13\> B\<12\> B\<11\> B\<10\> B\<9\> B\<8\> B\<7\> B\<6\> B\<5\> B\<4\> B\<3\> B\<2\> B\<1\> B\<0\> C\<31\> C\<30\> C\<29\> C\<28\> C\<27\> C\<26\> C\<25\> C\<24\> C\<23\> C\<22\> C\<21\> C\<20\> C\<19\> C\<18\> C\<17\> C\<16\> C\<15\> C\<14\> C\<13\> C\<12\> C\<11\> C\<10\> C\<9\> C\<8\> C\<7\> C\<6\> C\<5\> C\<4\> C\<3\> C\<2\> C\<1\> C\<0\> inh_gnd inh_gnds vdd_in inh_vdds
    UG160 (pwr_en pwr_en_bar inh_gnd inh_gnds vdd_in inh_vdds) LVT_invx2_PB4_AFBB
    alu_or_pwr_pmos (inh_vdd pwr_en_bar vdd_in inh_vdds) lvtpfet w=8000n l=30.00n nf=(2)*(1) ngcon=1 nsig_delvto_uo1=0 nsig_delvto_uo2=0 soa=1 swshe=0 swacc=0 swrg=0 swrsub=0 mismatch=1 m=1
    U1 (n32 C\<0\> inh_gnd inh_gnds inh_vdd inh_vdds) LVT_invx2_PB4_AFBB
    U29 (n31 C\<1\> inh_gnd inh_gnds inh_vdd inh_vdds) LVT_invx2_PB4_AFBB
    U9 (n30 C\<2\> inh_gnd inh_gnds inh_vdd inh_vdds) LVT_invx2_PB4_AFBB
    U28 (n29 C\<3\> inh_gnd inh_gnds inh_vdd inh_vdds) LVT_invx2_PB4_AFBB
    U8 (n28 C\<4\> inh_gnd inh_gnds inh_vdd inh_vdds) LVT_invx2_PB4_AFBB
    U32 (n27 C\<5\> inh_gnd inh_gnds inh_vdd inh_vdds) LVT_invx2_PB4_AFBB
    U31 (n26 C\<6\> inh_gnd inh_gnds inh_vdd inh_vdds) LVT_invx2_PB4_AFBB
    U30 (n25 C\<7\> inh_gnd inh_gnds inh_vdd inh_vdds) LVT_invx2_PB4_AFBB
    U7 (n24 C\<8\> inh_gnd inh_gnds inh_vdd inh_vdds) LVT_invx2_PB4_AFBB
    U27 (n23 C\<9\> inh_gnd inh_gnds inh_vdd inh_vdds) LVT_invx2_PB4_AFBB
    U26 (n22 C\<10\> inh_gnd inh_gnds inh_vdd inh_vdds) LVT_invx2_PB4_AFBB
    U6 (n21 C\<11\> inh_gnd inh_gnds inh_vdd inh_vdds) LVT_invx2_PB4_AFBB
    U25 (n20 C\<12\> inh_gnd inh_gnds inh_vdd inh_vdds) LVT_invx2_PB4_AFBB
    U24 (n19 C\<13\> inh_gnd inh_gnds inh_vdd inh_vdds) LVT_invx2_PB4_AFBB
    U23 (n18 C\<14\> inh_gnd inh_gnds inh_vdd inh_vdds) LVT_invx2_PB4_AFBB
    U5 (n17 C\<15\> inh_gnd inh_gnds inh_vdd inh_vdds) LVT_invx2_PB4_AFBB
    U22 (n16 C\<16\> inh_gnd inh_gnds inh_vdd inh_vdds) LVT_invx2_PB4_AFBB
    U21 (n15 C\<17\> inh_gnd inh_gnds inh_vdd inh_vdds) LVT_invx2_PB4_AFBB
    U20 (n14 C\<18\> inh_gnd inh_gnds inh_vdd inh_vdds) LVT_invx2_PB4_AFBB
    U4 (n13 C\<19\> inh_gnd inh_gnds inh_vdd inh_vdds) LVT_invx2_PB4_AFBB
    U19 (n12 C\<20\> inh_gnd inh_gnds inh_vdd inh_vdds) LVT_invx2_PB4_AFBB
    U18 (n11 C\<21\> inh_gnd inh_gnds inh_vdd inh_vdds) LVT_invx2_PB4_AFBB
    U3 (n10 C\<22\> inh_gnd inh_gnds inh_vdd inh_vdds) LVT_invx2_PB4_AFBB
    U17 (n9 C\<23\> inh_gnd inh_gnds inh_vdd inh_vdds) LVT_invx2_PB4_AFBB
    U16 (n8 C\<24\> inh_gnd inh_gnds inh_vdd inh_vdds) LVT_invx2_PB4_AFBB
    U15 (n7 C\<25\> inh_gnd inh_gnds inh_vdd inh_vdds) LVT_invx2_PB4_AFBB
    U2 (n6 C\<26\> inh_gnd inh_gnds inh_vdd inh_vdds) LVT_invx2_PB4_AFBB
    U14 (n5 C\<27\> inh_gnd inh_gnds inh_vdd inh_vdds) LVT_invx2_PB4_AFBB
    U13 (n4 C\<28\> inh_gnd inh_gnds inh_vdd inh_vdds) LVT_invx2_PB4_AFBB
    U12 (n3 C\<29\> inh_gnd inh_gnds inh_vdd inh_vdds) LVT_invx2_PB4_AFBB
    U11 (n2 C\<30\> inh_gnd inh_gnds inh_vdd inh_vdds) LVT_invx2_PB4_AFBB
    U10 (n1 C\<31\> inh_gnd inh_gnds inh_vdd inh_vdds) LVT_invx2_PB4_AFBB
    U64 (A\<0\> B\<0\> n32 inh_gnd inh_gnds inh_vdd inh_vdds) LVT_NOR2x1_PB4_AFBB
    U63 (A\<1\> B\<1\> n31 inh_gnd inh_gnds inh_vdd inh_vdds) LVT_NOR2x1_PB4_AFBB
    U62 (A\<2\> B\<2\> n30 inh_gnd inh_gnds inh_vdd inh_vdds) LVT_NOR2x1_PB4_AFBB
    U61 (A\<3\> B\<3\> n29 inh_gnd inh_gnds inh_vdd inh_vdds) LVT_NOR2x1_PB4_AFBB
    U60 (A\<4\> B\<4\> n28 inh_gnd inh_gnds inh_vdd inh_vdds) LVT_NOR2x1_PB4_AFBB
    U59 (A\<5\> B\<5\> n27 inh_gnd inh_gnds inh_vdd inh_vdds) LVT_NOR2x1_PB4_AFBB
    U58 (A\<6\> B\<6\> n26 inh_gnd inh_gnds inh_vdd inh_vdds) LVT_NOR2x1_PB4_AFBB
    U57 (A\<7\> B\<7\> n25 inh_gnd inh_gnds inh_vdd inh_vdds) LVT_NOR2x1_PB4_AFBB
    U56 (A\<8\> B\<8\> n24 inh_gnd inh_gnds inh_vdd inh_vdds) LVT_NOR2x1_PB4_AFBB
    U55 (A\<9\> B\<9\> n23 inh_gnd inh_gnds inh_vdd inh_vdds) LVT_NOR2x1_PB4_AFBB
    U54 (A\<10\> B\<10\> n22 inh_gnd inh_gnds inh_vdd inh_vdds) LVT_NOR2x1_PB4_AFBB
    U53 (A\<11\> B\<11\> n21 inh_gnd inh_gnds inh_vdd inh_vdds) LVT_NOR2x1_PB4_AFBB
    U52 (A\<12\> B\<12\> n20 inh_gnd inh_gnds inh_vdd inh_vdds) LVT_NOR2x1_PB4_AFBB
    U51 (A\<13\> B\<13\> n19 inh_gnd inh_gnds inh_vdd inh_vdds) LVT_NOR2x1_PB4_AFBB
    U50 (A\<14\> B\<14\> n18 inh_gnd inh_gnds inh_vdd inh_vdds) LVT_NOR2x1_PB4_AFBB
    U49 (A\<15\> B\<15\> n17 inh_gnd inh_gnds inh_vdd inh_vdds) LVT_NOR2x1_PB4_AFBB
    U48 (A\<16\> B\<16\> n16 inh_gnd inh_gnds inh_vdd inh_vdds) LVT_NOR2x1_PB4_AFBB
    U47 (A\<17\> B\<17\> n15 inh_gnd inh_gnds inh_vdd inh_vdds) LVT_NOR2x1_PB4_AFBB
    U46 (A\<18\> B\<18\> n14 inh_gnd inh_gnds inh_vdd inh_vdds) LVT_NOR2x1_PB4_AFBB
    U45 (A\<19\> B\<19\> n13 inh_gnd inh_gnds inh_vdd inh_vdds) LVT_NOR2x1_PB4_AFBB
    U44 (A\<20\> B\<20\> n12 inh_gnd inh_gnds inh_vdd inh_vdds) LVT_NOR2x1_PB4_AFBB
    U43 (A\<21\> B\<21\> n11 inh_gnd inh_gnds inh_vdd inh_vdds) LVT_NOR2x1_PB4_AFBB
    U42 (A\<22\> B\<22\> n10 inh_gnd inh_gnds inh_vdd inh_vdds) LVT_NOR2x1_PB4_AFBB
    U41 (A\<23\> B\<23\> n9 inh_gnd inh_gnds inh_vdd inh_vdds) LVT_NOR2x1_PB4_AFBB
    U40 (A\<24\> B\<24\> n8 inh_gnd inh_gnds inh_vdd inh_vdds) LVT_NOR2x1_PB4_AFBB
    U39 (A\<25\> B\<25\> n7 inh_gnd inh_gnds inh_vdd inh_vdds) LVT_NOR2x1_PB4_AFBB
    U38 (A\<26\> B\<26\> n6 inh_gnd inh_gnds inh_vdd inh_vdds) LVT_NOR2x1_PB4_AFBB
    U37 (A\<27\> B\<27\> n5 inh_gnd inh_gnds inh_vdd inh_vdds) LVT_NOR2x1_PB4_AFBB
    U36 (A\<28\> B\<28\> n4 inh_gnd inh_gnds inh_vdd inh_vdds) LVT_NOR2x1_PB4_AFBB
    U35 (A\<29\> B\<29\> n3 inh_gnd inh_gnds inh_vdd inh_vdds) LVT_NOR2x1_PB4_AFBB
    U34 (A\<30\> B\<30\> n2 inh_gnd inh_gnds inh_vdd inh_vdds) LVT_NOR2x1_PB4_AFBB
    U33 (A\<31\> B\<31\> n1 inh_gnd inh_gnds inh_vdd inh_vdds) LVT_NOR2x1_PB4_AFBB
ends alu_or

// power_gating_fine/alu_xor/schematic
subckt alu_xor pwr_en A\<31\> A\<30\> A\<29\> A\<28\> A\<27\> A\<26\> A\<25\> A\<24\> A\<23\> A\<22\> A\<21\> A\<20\> A\<19\> A\<18\> A\<17\> A\<16\> A\<15\> A\<14\> A\<13\> A\<12\> A\<11\> A\<10\> A\<9\> A\<8\> A\<7\> A\<6\> A\<5\> A\<4\> A\<3\> A\<2\> A\<1\> A\<0\> B\<31\> B\<30\> B\<29\> B\<28\> B\<27\> B\<26\> B\<25\> B\<24\> B\<23\> B\<22\> B\<21\> B\<20\> B\<19\> B\<18\> B\<17\> B\<16\> B\<15\> B\<14\> B\<13\> B\<12\> B\<11\> B\<10\> B\<9\> B\<8\> B\<7\> B\<6\> B\<5\> B\<4\> B\<3\> B\<2\> B\<1\> B\<0\> C\<31\> C\<30\> C\<29\> C\<28\> C\<27\> C\<26\> C\<25\> C\<24\> C\<23\> C\<22\> C\<21\> C\<20\> C\<19\> C\<18\> C\<17\> C\<16\> C\<15\> C\<14\> C\<13\> C\<12\> C\<11\> C\<10\> C\<9\> C\<8\> C\<7\> C\<6\> C\<5\> C\<4\> C\<3\> C\<2\> C\<1\> C\<0\> inh_gnd inh_gnds vdd_in inh_vdds
    UG160 (pwr_en pwr_en_bar inh_gnd inh_gnds vdd_in inh_vdds) LVT_invx2_PB4_AFBB
    alu_xor_pwr_pmos (inh_vdd pwr_en_bar vdd_in inh_vdds) lvtpfet w=8000n l=30.00n nf=(2)*(1) ngcon=1 nsig_delvto_uo1=0 nsig_delvto_uo2=0 soa=1 swshe=0 swacc=0 swrg=0 swrsub=0 mismatch=1 m=1
    U95 (A\<0\> n32 inh_gnd inh_gnds inh_vdd inh_vdds) LVT_invx2_PB4_AFBB
    U32 (n160 n157 inh_gnd inh_gnds inh_vdd inh_vdds) LVT_invx2_PB4_AFBB
    U96 (A\<0\> n159 inh_gnd inh_gnds inh_vdd inh_vdds) LVT_invx2_PB4_AFBB
    U31 (n116 n113 inh_gnd inh_gnds inh_vdd inh_vdds) LVT_invx2_PB4_AFBB
    U93 (A\<1\> n31 inh_gnd inh_gnds inh_vdd inh_vdds) LVT_invx2_PB4_AFBB
    U94 (A\<1\> n115 inh_gnd inh_gnds inh_vdd inh_vdds) LVT_invx2_PB4_AFBB
    U8 (n72 n69 inh_gnd inh_gnds inh_vdd inh_vdds) LVT_invx2_PB4_AFBB
    U91 (A\<2\> n30 inh_gnd inh_gnds inh_vdd inh_vdds) LVT_invx2_PB4_AFBB
    U92 (A\<2\> n71 inh_gnd inh_gnds inh_vdd inh_vdds) LVT_invx2_PB4_AFBB
    U30 (n60 n57 inh_gnd inh_gnds inh_vdd inh_vdds) LVT_invx2_PB4_AFBB
    U89 (A\<3\> n29 inh_gnd inh_gnds inh_vdd inh_vdds) LVT_invx2_PB4_AFBB
    U90 (A\<3\> n59 inh_gnd inh_gnds inh_vdd inh_vdds) LVT_invx2_PB4_AFBB
    U7 (n56 n53 inh_gnd inh_gnds inh_vdd inh_vdds) LVT_invx2_PB4_AFBB
    U87 (A\<4\> n28 inh_gnd inh_gnds inh_vdd inh_vdds) LVT_invx2_PB4_AFBB
    U88 (A\<4\> n55 inh_gnd inh_gnds inh_vdd inh_vdds) LVT_invx2_PB4_AFBB
    U29 (n52 n49 inh_gnd inh_gnds inh_vdd inh_vdds) LVT_invx2_PB4_AFBB
    U85 (A\<5\> n27 inh_gnd inh_gnds inh_vdd inh_vdds) LVT_invx2_PB4_AFBB
    U86 (A\<5\> n51 inh_gnd inh_gnds inh_vdd inh_vdds) LVT_invx2_PB4_AFBB
    U28 (n48 n45 inh_gnd inh_gnds inh_vdd inh_vdds) LVT_invx2_PB4_AFBB
    U83 (A\<6\> n26 inh_gnd inh_gnds inh_vdd inh_vdds) LVT_invx2_PB4_AFBB
    U84 (A\<6\> n47 inh_gnd inh_gnds inh_vdd inh_vdds) LVT_invx2_PB4_AFBB
    U27 (n44 n41 inh_gnd inh_gnds inh_vdd inh_vdds) LVT_invx2_PB4_AFBB
    U81 (A\<7\> n25 inh_gnd inh_gnds inh_vdd inh_vdds) LVT_invx2_PB4_AFBB
    U82 (A\<7\> n43 inh_gnd inh_gnds inh_vdd inh_vdds) LVT_invx2_PB4_AFBB
    U6 (n40 n37 inh_gnd inh_gnds inh_vdd inh_vdds) LVT_invx2_PB4_AFBB
    U79 (A\<8\> n24 inh_gnd inh_gnds inh_vdd inh_vdds) LVT_invx2_PB4_AFBB
    U80 (A\<8\> n39 inh_gnd inh_gnds inh_vdd inh_vdds) LVT_invx2_PB4_AFBB
    U26 (n36 n33 inh_gnd inh_gnds inh_vdd inh_vdds) LVT_invx2_PB4_AFBB
    U77 (A\<9\> n23 inh_gnd inh_gnds inh_vdd inh_vdds) LVT_invx2_PB4_AFBB
    U78 (A\<9\> n35 inh_gnd inh_gnds inh_vdd inh_vdds) LVT_invx2_PB4_AFBB
    U25 (n156 n153 inh_gnd inh_gnds inh_vdd inh_vdds) LVT_invx2_PB4_AFBB
    U75 (A\<10\> n22 inh_gnd inh_gnds inh_vdd inh_vdds) LVT_invx2_PB4_AFBB
    U76 (A\<10\> n155 inh_gnd inh_gnds inh_vdd inh_vdds) LVT_invx2_PB4_AFBB
    U5 (n152 n149 inh_gnd inh_gnds inh_vdd inh_vdds) LVT_invx2_PB4_AFBB
    U73 (A\<11\> n21 inh_gnd inh_gnds inh_vdd inh_vdds) LVT_invx2_PB4_AFBB
    U74 (A\<11\> n151 inh_gnd inh_gnds inh_vdd inh_vdds) LVT_invx2_PB4_AFBB
    U24 (n148 n145 inh_gnd inh_gnds inh_vdd inh_vdds) LVT_invx2_PB4_AFBB
    U71 (A\<12\> n20 inh_gnd inh_gnds inh_vdd inh_vdds) LVT_invx2_PB4_AFBB
    U72 (A\<12\> n147 inh_gnd inh_gnds inh_vdd inh_vdds) LVT_invx2_PB4_AFBB
    U23 (n144 n141 inh_gnd inh_gnds inh_vdd inh_vdds) LVT_invx2_PB4_AFBB
    U69 (A\<13\> n19 inh_gnd inh_gnds inh_vdd inh_vdds) LVT_invx2_PB4_AFBB
    U70 (A\<13\> n143 inh_gnd inh_gnds inh_vdd inh_vdds) LVT_invx2_PB4_AFBB
    U22 (n140 n137 inh_gnd inh_gnds inh_vdd inh_vdds) LVT_invx2_PB4_AFBB
    U67 (A\<14\> n18 inh_gnd inh_gnds inh_vdd inh_vdds) LVT_invx2_PB4_AFBB
    U68 (A\<14\> n139 inh_gnd inh_gnds inh_vdd inh_vdds) LVT_invx2_PB4_AFBB
    U4 (n136 n133 inh_gnd inh_gnds inh_vdd inh_vdds) LVT_invx2_PB4_AFBB
    U65 (A\<15\> n17 inh_gnd inh_gnds inh_vdd inh_vdds) LVT_invx2_PB4_AFBB
    U66 (A\<15\> n135 inh_gnd inh_gnds inh_vdd inh_vdds) LVT_invx2_PB4_AFBB
    U21 (n132 n129 inh_gnd inh_gnds inh_vdd inh_vdds) LVT_invx2_PB4_AFBB
    U63 (A\<16\> n16 inh_gnd inh_gnds inh_vdd inh_vdds) LVT_invx2_PB4_AFBB
    U64 (A\<16\> n131 inh_gnd inh_gnds inh_vdd inh_vdds) LVT_invx2_PB4_AFBB
    U20 (n128 n125 inh_gnd inh_gnds inh_vdd inh_vdds) LVT_invx2_PB4_AFBB
    U61 (A\<17\> n15 inh_gnd inh_gnds inh_vdd inh_vdds) LVT_invx2_PB4_AFBB
    U62 (A\<17\> n127 inh_gnd inh_gnds inh_vdd inh_vdds) LVT_invx2_PB4_AFBB
    U19 (n124 n121 inh_gnd inh_gnds inh_vdd inh_vdds) LVT_invx2_PB4_AFBB
    U59 (A\<18\> n14 inh_gnd inh_gnds inh_vdd inh_vdds) LVT_invx2_PB4_AFBB
    U60 (A\<18\> n123 inh_gnd inh_gnds inh_vdd inh_vdds) LVT_invx2_PB4_AFBB
    U3 (n120 n117 inh_gnd inh_gnds inh_vdd inh_vdds) LVT_invx2_PB4_AFBB
    U57 (A\<19\> n13 inh_gnd inh_gnds inh_vdd inh_vdds) LVT_invx2_PB4_AFBB
    U58 (A\<19\> n119 inh_gnd inh_gnds inh_vdd inh_vdds) LVT_invx2_PB4_AFBB
    U18 (n112 n109 inh_gnd inh_gnds inh_vdd inh_vdds) LVT_invx2_PB4_AFBB
    U55 (A\<20\> n12 inh_gnd inh_gnds inh_vdd inh_vdds) LVT_invx2_PB4_AFBB
    U56 (A\<20\> n111 inh_gnd inh_gnds inh_vdd inh_vdds) LVT_invx2_PB4_AFBB
    U17 (n108 n105 inh_gnd inh_gnds inh_vdd inh_vdds) LVT_invx2_PB4_AFBB
    U53 (A\<21\> n11 inh_gnd inh_gnds inh_vdd inh_vdds) LVT_invx2_PB4_AFBB
    U54 (A\<21\> n107 inh_gnd inh_gnds inh_vdd inh_vdds) LVT_invx2_PB4_AFBB
    U2 (n104 n101 inh_gnd inh_gnds inh_vdd inh_vdds) LVT_invx2_PB4_AFBB
    U51 (A\<22\> n10 inh_gnd inh_gnds inh_vdd inh_vdds) LVT_invx2_PB4_AFBB
    U52 (A\<22\> n103 inh_gnd inh_gnds inh_vdd inh_vdds) LVT_invx2_PB4_AFBB
    U16 (n100 n97 inh_gnd inh_gnds inh_vdd inh_vdds) LVT_invx2_PB4_AFBB
    U49 (A\<23\> n9 inh_gnd inh_gnds inh_vdd inh_vdds) LVT_invx2_PB4_AFBB
    U50 (A\<23\> n99 inh_gnd inh_gnds inh_vdd inh_vdds) LVT_invx2_PB4_AFBB
    U15 (n96 n93 inh_gnd inh_gnds inh_vdd inh_vdds) LVT_invx2_PB4_AFBB
    U47 (A\<24\> n8 inh_gnd inh_gnds inh_vdd inh_vdds) LVT_invx2_PB4_AFBB
    U48 (A\<24\> n95 inh_gnd inh_gnds inh_vdd inh_vdds) LVT_invx2_PB4_AFBB
    U45 (A\<25\> n7 inh_gnd inh_gnds inh_vdd inh_vdds) LVT_invx2_PB4_AFBB
    U14 (n92 n89 inh_gnd inh_gnds inh_vdd inh_vdds) LVT_invx2_PB4_AFBB
    U46 (A\<25\> n91 inh_gnd inh_gnds inh_vdd inh_vdds) LVT_invx2_PB4_AFBB
    U1 (n88 n85 inh_gnd inh_gnds inh_vdd inh_vdds) LVT_invx2_PB4_AFBB
    U43 (A\<26\> n6 inh_gnd inh_gnds inh_vdd inh_vdds) LVT_invx2_PB4_AFBB
    U44 (A\<26\> n87 inh_gnd inh_gnds inh_vdd inh_vdds) LVT_invx2_PB4_AFBB
    U13 (n84 n81 inh_gnd inh_gnds inh_vdd inh_vdds) LVT_invx2_PB4_AFBB
    U41 (A\<27\> n5 inh_gnd inh_gnds inh_vdd inh_vdds) LVT_invx2_PB4_AFBB
    U42 (A\<27\> n83 inh_gnd inh_gnds inh_vdd inh_vdds) LVT_invx2_PB4_AFBB
    U12 (n80 n77 inh_gnd inh_gnds inh_vdd inh_vdds) LVT_invx2_PB4_AFBB
    U39 (A\<28\> n4 inh_gnd inh_gnds inh_vdd inh_vdds) LVT_invx2_PB4_AFBB
    U40 (A\<28\> n79 inh_gnd inh_gnds inh_vdd inh_vdds) LVT_invx2_PB4_AFBB
    U11 (n76 n73 inh_gnd inh_gnds inh_vdd inh_vdds) LVT_invx2_PB4_AFBB
    U37 (A\<29\> n3 inh_gnd inh_gnds inh_vdd inh_vdds) LVT_invx2_PB4_AFBB
    U38 (A\<29\> n75 inh_gnd inh_gnds inh_vdd inh_vdds) LVT_invx2_PB4_AFBB
    U10 (n68 n65 inh_gnd inh_gnds inh_vdd inh_vdds) LVT_invx2_PB4_AFBB
    U35 (A\<30\> n2 inh_gnd inh_gnds inh_vdd inh_vdds) LVT_invx2_PB4_AFBB
    U36 (A\<30\> n67 inh_gnd inh_gnds inh_vdd inh_vdds) LVT_invx2_PB4_AFBB
    U34 (A\<31\> n63 inh_gnd inh_gnds inh_vdd inh_vdds) LVT_invx2_PB4_AFBB
    U33 (A\<31\> n1 inh_gnd inh_gnds inh_vdd inh_vdds) LVT_invx2_PB4_AFBB
    U9 (n64 n61 inh_gnd inh_gnds inh_vdd inh_vdds) LVT_invx2_PB4_AFBB
    U192 (n32 B\<0\> n160 inh_gnd inh_gnds inh_vdd inh_vdds) LVT_NOR2x1_PB4_AFBB
    U159 (n31 B\<1\> n116 inh_gnd inh_gnds inh_vdd inh_vdds) LVT_NOR2x1_PB4_AFBB
    U126 (n30 B\<2\> n72 inh_gnd inh_gnds inh_vdd inh_vdds) LVT_NOR2x1_PB4_AFBB
    U117 (n29 B\<3\> n60 inh_gnd inh_gnds inh_vdd inh_vdds) LVT_NOR2x1_PB4_AFBB
    U114 (n28 B\<4\> n56 inh_gnd inh_gnds inh_vdd inh_vdds) LVT_NOR2x1_PB4_AFBB
    U111 (n27 B\<5\> n52 inh_gnd inh_gnds inh_vdd inh_vdds) LVT_NOR2x1_PB4_AFBB
    U108 (n26 B\<6\> n48 inh_gnd inh_gnds inh_vdd inh_vdds) LVT_NOR2x1_PB4_AFBB
    U105 (n25 B\<7\> n44 inh_gnd inh_gnds inh_vdd inh_vdds) LVT_NOR2x1_PB4_AFBB
    U102 (n24 B\<8\> n40 inh_gnd inh_gnds inh_vdd inh_vdds) LVT_NOR2x1_PB4_AFBB
    U99 (n23 B\<9\> n36 inh_gnd inh_gnds inh_vdd inh_vdds) LVT_NOR2x1_PB4_AFBB
    U189 (n22 B\<10\> n156 inh_gnd inh_gnds inh_vdd inh_vdds) LVT_NOR2x1_PB4_AFBB
    U186 (n21 B\<11\> n152 inh_gnd inh_gnds inh_vdd inh_vdds) LVT_NOR2x1_PB4_AFBB
    U183 (n20 B\<12\> n148 inh_gnd inh_gnds inh_vdd inh_vdds) LVT_NOR2x1_PB4_AFBB
    U180 (n19 B\<13\> n144 inh_gnd inh_gnds inh_vdd inh_vdds) LVT_NOR2x1_PB4_AFBB
    U177 (n18 B\<14\> n140 inh_gnd inh_gnds inh_vdd inh_vdds) LVT_NOR2x1_PB4_AFBB
    U174 (n17 B\<15\> n136 inh_gnd inh_gnds inh_vdd inh_vdds) LVT_NOR2x1_PB4_AFBB
    U171 (n16 B\<16\> n132 inh_gnd inh_gnds inh_vdd inh_vdds) LVT_NOR2x1_PB4_AFBB
    U168 (n15 B\<17\> n128 inh_gnd inh_gnds inh_vdd inh_vdds) LVT_NOR2x1_PB4_AFBB
    U165 (n14 B\<18\> n124 inh_gnd inh_gnds inh_vdd inh_vdds) LVT_NOR2x1_PB4_AFBB
    U162 (n13 B\<19\> n120 inh_gnd inh_gnds inh_vdd inh_vdds) LVT_NOR2x1_PB4_AFBB
    U156 (n12 B\<20\> n112 inh_gnd inh_gnds inh_vdd inh_vdds) LVT_NOR2x1_PB4_AFBB
    U153 (n11 B\<21\> n108 inh_gnd inh_gnds inh_vdd inh_vdds) LVT_NOR2x1_PB4_AFBB
    U150 (n10 B\<22\> n104 inh_gnd inh_gnds inh_vdd inh_vdds) LVT_NOR2x1_PB4_AFBB
    U147 (n9 B\<23\> n100 inh_gnd inh_gnds inh_vdd inh_vdds) LVT_NOR2x1_PB4_AFBB
    U144 (n8 B\<24\> n96 inh_gnd inh_gnds inh_vdd inh_vdds) LVT_NOR2x1_PB4_AFBB
    U141 (n7 B\<25\> n92 inh_gnd inh_gnds inh_vdd inh_vdds) LVT_NOR2x1_PB4_AFBB
    U138 (n6 B\<26\> n88 inh_gnd inh_gnds inh_vdd inh_vdds) LVT_NOR2x1_PB4_AFBB
    U135 (n5 B\<27\> n84 inh_gnd inh_gnds inh_vdd inh_vdds) LVT_NOR2x1_PB4_AFBB
    U132 (n4 B\<28\> n80 inh_gnd inh_gnds inh_vdd inh_vdds) LVT_NOR2x1_PB4_AFBB
    U129 (n3 B\<29\> n76 inh_gnd inh_gnds inh_vdd inh_vdds) LVT_NOR2x1_PB4_AFBB
    U123 (n2 B\<30\> n68 inh_gnd inh_gnds inh_vdd inh_vdds) LVT_NOR2x1_PB4_AFBB
    U120 (n1 B\<31\> n64 inh_gnd inh_gnds inh_vdd inh_vdds) LVT_NOR2x1_PB4_AFBB
    U190 (n157 n158 xor_res\<0\> inh_gnd inh_gnds inh_vdd inh_vdds) LVT_NADN2x1_PB4_AFBB
    U191 (B\<0\> n159 n158 inh_gnd inh_gnds inh_vdd inh_vdds) LVT_NADN2x1_PB4_AFBB
    U158 (B\<1\> n115 n114 inh_gnd inh_gnds inh_vdd inh_vdds) LVT_NADN2x1_PB4_AFBB
    U157 (n113 n114 xor_res\<1\> inh_gnd inh_gnds inh_vdd inh_vdds) LVT_NADN2x1_PB4_AFBB
    U125 (B\<2\> n71 n70 inh_gnd inh_gnds inh_vdd inh_vdds) LVT_NADN2x1_PB4_AFBB
    U124 (n69 n70 xor_res\<2\> inh_gnd inh_gnds inh_vdd inh_vdds) LVT_NADN2x1_PB4_AFBB
    U116 (B\<3\> n59 n58 inh_gnd inh_gnds inh_vdd inh_vdds) LVT_NADN2x1_PB4_AFBB
    U115 (n57 n58 xor_res\<3\> inh_gnd inh_gnds inh_vdd inh_vdds) LVT_NADN2x1_PB4_AFBB
    U113 (B\<4\> n55 n54 inh_gnd inh_gnds inh_vdd inh_vdds) LVT_NADN2x1_PB4_AFBB
    U112 (n53 n54 xor_res\<4\> inh_gnd inh_gnds inh_vdd inh_vdds) LVT_NADN2x1_PB4_AFBB
    U110 (B\<5\> n51 n50 inh_gnd inh_gnds inh_vdd inh_vdds) LVT_NADN2x1_PB4_AFBB
    U109 (n49 n50 xor_res\<5\> inh_gnd inh_gnds inh_vdd inh_vdds) LVT_NADN2x1_PB4_AFBB
    U107 (B\<6\> n47 n46 inh_gnd inh_gnds inh_vdd inh_vdds) LVT_NADN2x1_PB4_AFBB
    U106 (n45 n46 xor_res\<6\> inh_gnd inh_gnds inh_vdd inh_vdds) LVT_NADN2x1_PB4_AFBB
    U104 (B\<7\> n43 n42 inh_gnd inh_gnds inh_vdd inh_vdds) LVT_NADN2x1_PB4_AFBB
    U103 (n41 n42 xor_res\<7\> inh_gnd inh_gnds inh_vdd inh_vdds) LVT_NADN2x1_PB4_AFBB
    U101 (B\<8\> n39 n38 inh_gnd inh_gnds inh_vdd inh_vdds) LVT_NADN2x1_PB4_AFBB
    U100 (n37 n38 xor_res\<8\> inh_gnd inh_gnds inh_vdd inh_vdds) LVT_NADN2x1_PB4_AFBB
    U98 (B\<9\> n35 n34 inh_gnd inh_gnds inh_vdd inh_vdds) LVT_NADN2x1_PB4_AFBB
    U97 (n33 n34 xor_res\<9\> inh_gnd inh_gnds inh_vdd inh_vdds) LVT_NADN2x1_PB4_AFBB
    U188 (B\<10\> n155 n154 inh_gnd inh_gnds inh_vdd inh_vdds) LVT_NADN2x1_PB4_AFBB
    U187 (n153 n154 xor_res\<10\> inh_gnd inh_gnds inh_vdd inh_vdds) LVT_NADN2x1_PB4_AFBB
    U185 (B\<11\> n151 n150 inh_gnd inh_gnds inh_vdd inh_vdds) LVT_NADN2x1_PB4_AFBB
    U184 (n149 n150 xor_res\<11\> inh_gnd inh_gnds inh_vdd inh_vdds) LVT_NADN2x1_PB4_AFBB
    U182 (B\<12\> n147 n146 inh_gnd inh_gnds inh_vdd inh_vdds) LVT_NADN2x1_PB4_AFBB
    U181 (n145 n146 xor_res\<12\> inh_gnd inh_gnds inh_vdd inh_vdds) LVT_NADN2x1_PB4_AFBB
    U179 (B\<13\> n143 n142 inh_gnd inh_gnds inh_vdd inh_vdds) LVT_NADN2x1_PB4_AFBB
    U178 (n141 n142 xor_res\<13\> inh_gnd inh_gnds inh_vdd inh_vdds) LVT_NADN2x1_PB4_AFBB
    U176 (B\<14\> n139 n138 inh_gnd inh_gnds inh_vdd inh_vdds) LVT_NADN2x1_PB4_AFBB
    U175 (n137 n138 xor_res\<14\> inh_gnd inh_gnds inh_vdd inh_vdds) LVT_NADN2x1_PB4_AFBB
    U173 (B\<15\> n135 n134 inh_gnd inh_gnds inh_vdd inh_vdds) LVT_NADN2x1_PB4_AFBB
    U172 (n133 n134 xor_res\<15\> inh_gnd inh_gnds inh_vdd inh_vdds) LVT_NADN2x1_PB4_AFBB
    U170 (B\<16\> n131 n130 inh_gnd inh_gnds inh_vdd inh_vdds) LVT_NADN2x1_PB4_AFBB
    U169 (n129 n130 xor_res\<16\> inh_gnd inh_gnds inh_vdd inh_vdds) LVT_NADN2x1_PB4_AFBB
    U167 (B\<17\> n127 n126 inh_gnd inh_gnds inh_vdd inh_vdds) LVT_NADN2x1_PB4_AFBB
    U166 (n125 n126 xor_res\<17\> inh_gnd inh_gnds inh_vdd inh_vdds) LVT_NADN2x1_PB4_AFBB
    U164 (B\<18\> n123 n122 inh_gnd inh_gnds inh_vdd inh_vdds) LVT_NADN2x1_PB4_AFBB
    U163 (n121 n122 xor_res\<18\> inh_gnd inh_gnds inh_vdd inh_vdds) LVT_NADN2x1_PB4_AFBB
    U161 (B\<19\> n119 n118 inh_gnd inh_gnds inh_vdd inh_vdds) LVT_NADN2x1_PB4_AFBB
    U160 (n117 n118 xor_res\<19\> inh_gnd inh_gnds inh_vdd inh_vdds) LVT_NADN2x1_PB4_AFBB
    U155 (B\<20\> n111 n110 inh_gnd inh_gnds inh_vdd inh_vdds) LVT_NADN2x1_PB4_AFBB
    U154 (n109 n110 xor_res\<20\> inh_gnd inh_gnds inh_vdd inh_vdds) LVT_NADN2x1_PB4_AFBB
    U152 (B\<21\> n107 n106 inh_gnd inh_gnds inh_vdd inh_vdds) LVT_NADN2x1_PB4_AFBB
    U151 (n105 n106 xor_res\<21\> inh_gnd inh_gnds inh_vdd inh_vdds) LVT_NADN2x1_PB4_AFBB
    U149 (B\<22\> n103 n102 inh_gnd inh_gnds inh_vdd inh_vdds) LVT_NADN2x1_PB4_AFBB
    U148 (n101 n102 xor_res\<22\> inh_gnd inh_gnds inh_vdd inh_vdds) LVT_NADN2x1_PB4_AFBB
    U146 (B\<23\> n99 n98 inh_gnd inh_gnds inh_vdd inh_vdds) LVT_NADN2x1_PB4_AFBB
    U145 (n97 n98 xor_res\<23\> inh_gnd inh_gnds inh_vdd inh_vdds) LVT_NADN2x1_PB4_AFBB
    U143 (B\<24\> n95 n94 inh_gnd inh_gnds inh_vdd inh_vdds) LVT_NADN2x1_PB4_AFBB
    U142 (n93 n94 xor_res\<24\> inh_gnd inh_gnds inh_vdd inh_vdds) LVT_NADN2x1_PB4_AFBB
    U139 (n89 n90 xor_res\<25\> inh_gnd inh_gnds inh_vdd inh_vdds) LVT_NADN2x1_PB4_AFBB
    U140 (B\<25\> n91 n90 inh_gnd inh_gnds inh_vdd inh_vdds) LVT_NADN2x1_PB4_AFBB
    U137 (B\<26\> n87 n86 inh_gnd inh_gnds inh_vdd inh_vdds) LVT_NADN2x1_PB4_AFBB
    U136 (n85 n86 xor_res\<26\> inh_gnd inh_gnds inh_vdd inh_vdds) LVT_NADN2x1_PB4_AFBB
    U134 (B\<27\> n83 n82 inh_gnd inh_gnds inh_vdd inh_vdds) LVT_NADN2x1_PB4_AFBB
    U133 (n81 n82 xor_res\<27\> inh_gnd inh_gnds inh_vdd inh_vdds) LVT_NADN2x1_PB4_AFBB
    U131 (B\<28\> n79 n78 inh_gnd inh_gnds inh_vdd inh_vdds) LVT_NADN2x1_PB4_AFBB
    U130 (n77 n78 xor_res\<28\> inh_gnd inh_gnds inh_vdd inh_vdds) LVT_NADN2x1_PB4_AFBB
    U128 (B\<29\> n75 n74 inh_gnd inh_gnds inh_vdd inh_vdds) LVT_NADN2x1_PB4_AFBB
    U127 (n73 n74 xor_res\<29\> inh_gnd inh_gnds inh_vdd inh_vdds) LVT_NADN2x1_PB4_AFBB
    U122 (B\<30\> n67 n66 inh_gnd inh_gnds inh_vdd inh_vdds) LVT_NADN2x1_PB4_AFBB
    U121 (n65 n66 xor_res\<30\> inh_gnd inh_gnds inh_vdd inh_vdds) LVT_NADN2x1_PB4_AFBB
    U119 (B\<31\> n63 n62 inh_gnd inh_gnds inh_vdd inh_vdds) LVT_NADN2x1_PB4_AFBB
    U118 (n61 n62 xor_res\<31\> inh_gnd inh_gnds inh_vdd inh_vdds) LVT_NADN2x1_PB4_AFBB
    Thru31 (xor_res\<0\> C\<0\>) iprobe
    Thru30 (xor_res\<1\> C\<1\>) iprobe
    Thru29 (xor_res\<2\> C\<2\>) iprobe
    Thru28 (xor_res\<3\> C\<3\>) iprobe
    Thru27 (xor_res\<4\> C\<4\>) iprobe
    Thru26 (xor_res\<5\> C\<5\>) iprobe
    Thru25 (xor_res\<6\> C\<6\>) iprobe
    Thru24 (xor_res\<7\> C\<7\>) iprobe
    Thru23 (xor_res\<8\> C\<8\>) iprobe
    Thru22 (xor_res\<9\> C\<9\>) iprobe
    Thru21 (xor_res\<10\> C\<10\>) iprobe
    Thru20 (xor_res\<11\> C\<11\>) iprobe
    Thru19 (xor_res\<12\> C\<12\>) iprobe
    Thru18 (xor_res\<13\> C\<13\>) iprobe
    Thru17 (xor_res\<14\> C\<14\>) iprobe
    Thru16 (xor_res\<15\> C\<15\>) iprobe
    Thru15 (xor_res\<16\> C\<16\>) iprobe
    Thru14 (xor_res\<17\> C\<17\>) iprobe
    Thru13 (xor_res\<18\> C\<18\>) iprobe
    Thru12 (xor_res\<19\> C\<19\>) iprobe
    Thru11 (xor_res\<20\> C\<20\>) iprobe
    Thru10 (xor_res\<21\> C\<21\>) iprobe
    Thru9 (xor_res\<22\> C\<22\>) iprobe
    Thru8 (xor_res\<23\> C\<23\>) iprobe
    Thru7 (xor_res\<24\> C\<24\>) iprobe
    Thru6 (xor_res\<25\> C\<25\>) iprobe
    Thru5 (xor_res\<26\> C\<26\>) iprobe
    Thru4 (xor_res\<27\> C\<27\>) iprobe
    Thru3 (xor_res\<28\> C\<28\>) iprobe
    Thru2 (xor_res\<29\> C\<29\>) iprobe
    Thru1 (xor_res\<30\> C\<30\>) iprobe
    Thru0 (xor_res\<31\> C\<31\>) iprobe
ends alu_xor

// power_gating_fine/alu_sll/schematic
subckt alu_sll pwr_en A\<31\> A\<30\> A\<29\> A\<28\> A\<27\> A\<26\> A\<25\> A\<24\> A\<23\> A\<22\> A\<21\> A\<20\> A\<19\> A\<18\> A\<17\> A\<16\> A\<15\> A\<14\> A\<13\> A\<12\> A\<11\> A\<10\> A\<9\> A\<8\> A\<7\> A\<6\> A\<5\> A\<4\> A\<3\> A\<2\> A\<1\> A\<0\> B\<4\> B\<3\> B\<2\> B\<1\> B\<0\> C\<31\> C\<30\> C\<29\> C\<28\> C\<27\> C\<26\> C\<25\> C\<24\> C\<23\> C\<22\> C\<21\> C\<20\> C\<19\> C\<18\> C\<17\> C\<16\> C\<15\> C\<14\> C\<13\> C\<12\> C\<11\> C\<10\> C\<9\> C\<8\> C\<7\> C\<6\> C\<5\> C\<4\> C\<3\> C\<2\> C\<1\> C\<0\> inh_gnd inh_gnds vdd_in inh_vdds
    UG160 (pwr_en pwr_en_bar inh_gnd inh_gnds vdd_in inh_vdds) LVT_invx2_PB4_AFBB
    alu_sll_pwr_pmos (inh_vdd pwr_en_bar vdd_in inh_vdds) lvtpfet w=8000n l=30.00n nf=(2)*(1) ngcon=1 nsig_delvto_uo1=0 nsig_delvto_uo2=0 soa=1 swshe=0 swacc=0 swrg=0 swrsub=0 mismatch=1 m=1
    U174 (B\<4\> n127 inh_gnd inh_gnds inh_vdd inh_vdds) LVT_invx2_PB4_AFBB
    U182 (n169 n135 inh_gnd inh_gnds inh_vdd inh_vdds) LVT_invx2_PB4_AFBB
    U37 (A\<26\> n29 inh_gnd inh_gnds inh_vdd inh_vdds) LVT_invx2_PB4_AFBB
    U92 (A\<28\> n247 inh_gnd inh_gnds inh_vdd inh_vdds) LVT_invx2_PB4_AFBB
    U59 (A\<25\> n46 inh_gnd inh_gnds inh_vdd inh_vdds) LVT_invx2_PB4_AFBB
    U89 (A\<27\> n243 inh_gnd inh_gnds inh_vdd inh_vdds) LVT_invx2_PB4_AFBB
    U175 (B\<4\> n128 inh_gnd inh_gnds inh_vdd inh_vdds) LVT_invx2_PB4_AFBB
    U69 (B\<3\> n55 inh_gnd inh_gnds inh_vdd inh_vdds) LVT_invx2_PB4_AFBB
    U82 (A\<17\> n65 inh_gnd inh_gnds inh_vdd inh_vdds) LVT_invx2_PB4_AFBB
    U140 (A\<18\> n105 inh_gnd inh_gnds inh_vdd inh_vdds) LVT_invx2_PB4_AFBB
    U98 (A\<20\> n417 inh_gnd inh_gnds inh_vdd inh_vdds) LVT_invx2_PB4_AFBB
    U157 (A\<19\> n414 inh_gnd inh_gnds inh_vdd inh_vdds) LVT_invx2_PB4_AFBB
    U93 (A\<22\> n72 inh_gnd inh_gnds inh_vdd inh_vdds) LVT_invx2_PB4_AFBB
    U151 (A\<24\> n326 inh_gnd inh_gnds inh_vdd inh_vdds) LVT_invx2_PB4_AFBB
    U153 (A\<21\> n114 inh_gnd inh_gnds inh_vdd inh_vdds) LVT_invx2_PB4_AFBB
    U148 (A\<23\> n323 inh_gnd inh_gnds inh_vdd inh_vdds) LVT_invx2_PB4_AFBB
    U118 (A\<10\> n90 inh_gnd inh_gnds inh_vdd inh_vdds) LVT_invx2_PB4_AFBB
    U163 (A\<12\> n552 inh_gnd inh_gnds inh_vdd inh_vdds) LVT_invx2_PB4_AFBB
    U100 (A\<9\> n77 inh_gnd inh_gnds inh_vdd inh_vdds) LVT_invx2_PB4_AFBB
    U123 (A\<11\> n94 inh_gnd inh_gnds inh_vdd inh_vdds) LVT_invx2_PB4_AFBB
    U158 (A\<14\> n117 inh_gnd inh_gnds inh_vdd inh_vdds) LVT_invx2_PB4_AFBB
    U145 (A\<16\> n486 inh_gnd inh_gnds inh_vdd inh_vdds) LVT_invx2_PB4_AFBB
    U42 (A\<0\> n625 inh_gnd inh_gnds inh_vdd inh_vdds) LVT_invx2_PB4_AFBB
    U203 (B\<2\> n607 inh_gnd inh_gnds inh_vdd inh_vdds) LVT_invx2_PB4_AFBB
    U219 (n367 n346 inh_gnd inh_gnds inh_vdd inh_vdds) LVT_invx2_PB4_AFBB
    U196 (n514 n137 inh_gnd inh_gnds inh_vdd inh_vdds) LVT_invx2_PB4_AFBB
    U192 (n448 n203 inh_gnd inh_gnds inh_vdd inh_vdds) LVT_invx2_PB4_AFBB
    U195 (n380 n289 inh_gnd inh_gnds inh_vdd inh_vdds) LVT_invx2_PB4_AFBB
    U240 (n172 n175 inh_gnd inh_gnds inh_vdd inh_vdds) LVT_invx2_PB4_AFBB
    U188 (n519 n293 inh_gnd inh_gnds inh_vdd inh_vdds) LVT_invx2_PB4_AFBB
    U169 (n518 n383 inh_gnd inh_gnds inh_vdd inh_vdds) LVT_invx2_PB4_AFBB
    U17 (n519 n11 inh_gnd inh_gnds inh_vdd inh_vdds) LVT_invx2_PB4_AFBB
    U230 (n513 n165 inh_gnd inh_gnds inh_vdd inh_vdds) LVT_invx2_PB4_AFBB
    U221 (n47 n158 inh_gnd inh_gnds inh_vdd inh_vdds) LVT_invx2_PB4_AFBB
    U136 (n515 n371 inh_gnd inh_gnds inh_vdd inh_vdds) LVT_invx2_PB4_AFBB
    U191 (A\<2\> n617 inh_gnd inh_gnds inh_vdd inh_vdds) LVT_invx2_PB4_AFBB
    U79 (A\<4\> n63 inh_gnd inh_gnds inh_vdd inh_vdds) LVT_invx2_PB4_AFBB
    U35 (A\<1\> n28 inh_gnd inh_gnds inh_vdd inh_vdds) LVT_invx2_PB4_AFBB
    U227 (n162 n163 inh_gnd inh_gnds inh_vdd inh_vdds) LVT_invx2_PB4_AFBB
    U76 (A\<3\> n61 inh_gnd inh_gnds inh_vdd inh_vdds) LVT_invx2_PB4_AFBB
    U171 (n147 n124 inh_gnd inh_gnds inh_vdd inh_vdds) LVT_invx2_PB4_AFBB
    U55 (n42 n43 inh_gnd inh_gnds inh_vdd inh_vdds) LVT_invx2_PB4_AFBB
    U54 (n368 n42 inh_gnd inh_gnds inh_vdd inh_vdds) LVT_invx2_PB4_AFBB
    U113 (A\<6\> n595 inh_gnd inh_gnds inh_vdd inh_vdds) LVT_invx2_PB4_AFBB
    U108 (A\<8\> n82 inh_gnd inh_gnds inh_vdd inh_vdds) LVT_invx2_PB4_AFBB
    U138 (A\<5\> n104 inh_gnd inh_gnds inh_vdd inh_vdds) LVT_invx2_PB4_AFBB
    U106 (A\<7\> n81 inh_gnd inh_gnds inh_vdd inh_vdds) LVT_invx2_PB4_AFBB
    U71 (B\<4\> n57 inh_gnd inh_gnds inh_vdd inh_vdds) LVT_invx2_PB4_AFBB
    U15 (n188 sll_res\<8\> inh_gnd inh_gnds inh_vdd inh_vdds) LVT_invx2_PB4_AFBB
    U211 (n497 n391 inh_gnd inh_gnds inh_vdd inh_vdds) LVT_invx2_PB4_AFBB
    U96 (A\<20\> n74 inh_gnd inh_gnds inh_vdd inh_vdds) LVT_invx2_PB4_AFBB
    U141 (A\<18\> n106 inh_gnd inh_gnds inh_vdd inh_vdds) LVT_invx2_PB4_AFBB
    U128 (n162 n98 inh_gnd inh_gnds inh_vdd inh_vdds) LVT_invx2_PB4_AFBB
    U155 (A\<19\> n115 inh_gnd inh_gnds inh_vdd inh_vdds) LVT_invx2_PB4_AFBB
    U154 (A\<21\> n377 inh_gnd inh_gnds inh_vdd inh_vdds) LVT_invx2_PB4_AFBB
    U62 (n345 n48 inh_gnd inh_gnds inh_vdd inh_vdds) LVT_invx2_PB4_AFBB
    U46 (n343 n35 inh_gnd inh_gnds inh_vdd inh_vdds) LVT_invx2_PB4_AFBB
    U44 (n202 n33 inh_gnd inh_gnds inh_vdd inh_vdds) LVT_invx2_PB4_AFBB
    U214 (n151 n153 inh_gnd inh_gnds inh_vdd inh_vdds) LVT_invx2_PB4_AFBB
    U114 (n312 n86 inh_gnd inh_gnds inh_vdd inh_vdds) LVT_invx2_PB4_AFBB
    U125 (n198 n95 inh_gnd inh_gnds inh_vdd inh_vdds) LVT_invx2_PB4_AFBB
    U40 (A\<0\> n31 inh_gnd inh_gnds inh_vdd inh_vdds) LVT_invx2_PB4_AFBB
    U36 (A\<1\> n613 inh_gnd inh_gnds inh_vdd inh_vdds) LVT_invx2_PB4_AFBB
    U117 (A\<10\> n89 inh_gnd inh_gnds inh_vdd inh_vdds) LVT_invx2_PB4_AFBB
    U109 (A\<8\> n83 inh_gnd inh_gnds inh_vdd inh_vdds) LVT_invx2_PB4_AFBB
    U99 (A\<9\> n76 inh_gnd inh_gnds inh_vdd inh_vdds) LVT_invx2_PB4_AFBB
    U122 (A\<11\> n93 inh_gnd inh_gnds inh_vdd inh_vdds) LVT_invx2_PB4_AFBB
    U25 (n151 n19 inh_gnd inh_gnds inh_vdd inh_vdds) LVT_invx2_PB4_AFBB
    U5 (n246 n245 inh_gnd inh_gnds inh_vdd inh_vdds) LVT_invx2_PB4_AFBB
    U251 (n146 n184 inh_gnd inh_gnds inh_vdd inh_vdds) LVT_invx2_PB4_AFBB
    U213 (n151 n152 inh_gnd inh_gnds inh_vdd inh_vdds) LVT_invx2_PB4_AFBB
    U178 (n20 n131 inh_gnd inh_gnds inh_vdd inh_vdds) LVT_invx2_PB4_AFBB
    U173 (n162 n126 inh_gnd inh_gnds inh_vdd inh_vdds) LVT_invx2_PB4_AFBB
    U179 (n20 n132 inh_gnd inh_gnds inh_vdd inh_vdds) LVT_invx2_PB4_AFBB
    U27 (n20 n21 inh_gnd inh_gnds inh_vdd inh_vdds) LVT_invx2_PB4_AFBB
    U206 (n144 n146 inh_gnd inh_gnds inh_vdd inh_vdds) LVT_invx2_PB4_AFBB
    U204 (n145 n144 inh_gnd inh_gnds inh_vdd inh_vdds) LVT_invx2_PB4_AFBB
    U28 (n301 n217 inh_gnd inh_gnds inh_vdd inh_vdds) LVT_invx2_PB4_AFBB
    U57 (n228 n300 inh_gnd inh_gnds inh_vdd inh_vdds) LVT_invx2_PB4_AFBB
    U2 (n170 n1 inh_gnd inh_gnds inh_vdd inh_vdds) LVT_invx2_PB4_AFBB
    U187 (n207 sll_res\<31\> inh_gnd inh_gnds inh_vdd inh_vdds) LVT_invx2_PB4_AFBB
    U170 (n24 n472 inh_gnd inh_gnds inh_vdd inh_vdds) LVT_invx2_PB4_AFBB
    U7 (n402 n400 inh_gnd inh_gnds inh_vdd inh_vdds) LVT_invx2_PB4_AFBB
    U115 (n86 n87 inh_gnd inh_gnds inh_vdd inh_vdds) LVT_invx2_PB4_AFBB
    U116 (n86 n88 inh_gnd inh_gnds inh_vdd inh_vdds) LVT_invx2_PB4_AFBB
    U228 (B\<4\> n186 inh_gnd inh_gnds inh_vdd inh_vdds) LVT_invx2_PB4_AFBB
    U4 (n177 n3 inh_gnd inh_gnds inh_vdd inh_vdds) LVT_invx2_PB4_AFBB
    U43 (n308 n213 inh_gnd inh_gnds inh_vdd inh_vdds) LVT_invx2_PB4_AFBB
    U49 (B\<4\> n38 inh_gnd inh_gnds inh_vdd inh_vdds) LVT_invx2_PB4_AFBB
    U74 (n618 n311 inh_gnd inh_gnds inh_vdd inh_vdds) LVT_invx2_PB4_AFBB
    U48 (n35 n37 inh_gnd inh_gnds inh_vdd inh_vdds) LVT_invx2_PB4_AFBB
    U166 (n253 n122 inh_gnd inh_gnds inh_vdd inh_vdds) LVT_invx2_PB4_AFBB
    U223 (n157 n160 inh_gnd inh_gnds inh_vdd inh_vdds) LVT_invx2_PB4_AFBB
    U216 (n346 n154 inh_gnd inh_gnds inh_vdd inh_vdds) LVT_invx2_PB4_AFBB
    U212 (n225 n151 inh_gnd inh_gnds inh_vdd inh_vdds) LVT_invx2_PB4_AFBB
    U11 (B\<1\> n7 inh_gnd inh_gnds inh_vdd inh_vdds) LVT_invx2_PB4_AFBB
    U225 (B\<3\> n205 inh_gnd inh_gnds inh_vdd inh_vdds) LVT_invx2_PB4_AFBB
    U220 (n344 n157 inh_gnd inh_gnds inh_vdd inh_vdds) LVT_invx2_PB4_AFBB
    U215 (B\<1\> n663 inh_gnd inh_gnds inh_vdd inh_vdds) LVT_invx2_PB4_AFBB
    U248 (n241 n181 inh_gnd inh_gnds inh_vdd inh_vdds) LVT_invx2_PB4_AFBB
    U250 (n181 n183 inh_gnd inh_gnds inh_vdd inh_vdds) LVT_invx2_PB4_AFBB
    U207 (n183 n147 inh_gnd inh_gnds inh_vdd inh_vdds) LVT_invx2_PB4_AFBB
    U14 (n527 sll_res\<15\> inh_gnd inh_gnds inh_vdd inh_vdds) LVT_invx2_PB4_AFBB
    U73 (B\<4\> n59 inh_gnd inh_gnds inh_vdd inh_vdds) LVT_invx2_PB4_AFBB
    U183 (n636 n403 inh_gnd inh_gnds inh_vdd inh_vdds) LVT_invx2_PB4_AFBB
    U22 (n636 n16 inh_gnd inh_gnds inh_vdd inh_vdds) LVT_invx2_PB4_AFBB
    U224 (n157 n161 inh_gnd inh_gnds inh_vdd inh_vdds) LVT_invx2_PB4_AFBB
    U172 (n147 n125 inh_gnd inh_gnds inh_vdd inh_vdds) LVT_invx2_PB4_AFBB
    U56 (n300 n44 inh_gnd inh_gnds inh_vdd inh_vdds) LVT_invx2_PB4_AFBB
    U110 (A\<8\> n594 inh_gnd inh_gnds inh_vdd inh_vdds) LVT_invx2_PB4_AFBB
    U119 (A\<10\> n91 inh_gnd inh_gnds inh_vdd inh_vdds) LVT_invx2_PB4_AFBB
    U9 (n658 n5 inh_gnd inh_gnds inh_vdd inh_vdds) LVT_invx2_PB4_AFBB
    U105 (A\<7\> n80 inh_gnd inh_gnds inh_vdd inh_vdds) LVT_invx2_PB4_AFBB
    U101 (A\<9\> n602 inh_gnd inh_gnds inh_vdd inh_vdds) LVT_invx2_PB4_AFBB
    U51 (A\<29\> n242 inh_gnd inh_gnds inh_vdd inh_vdds) LVT_invx2_PB4_AFBB
    U88 (A\<27\> n69 inh_gnd inh_gnds inh_vdd inh_vdds) LVT_invx2_PB4_AFBB
    U91 (A\<28\> n71 inh_gnd inh_gnds inh_vdd inh_vdds) LVT_invx2_PB4_AFBB
    U233 (n135 n168 inh_gnd inh_gnds inh_vdd inh_vdds) LVT_invx2_PB4_AFBB
    U177 (B\<4\> n130 inh_gnd inh_gnds inh_vdd inh_vdds) LVT_invx2_PB4_AFBB
    U134 (n540 n252 inh_gnd inh_gnds inh_vdd inh_vdds) LVT_invx2_PB4_AFBB
    U200 (n140 n141 inh_gnd inh_gnds inh_vdd inh_vdds) LVT_invx2_PB4_AFBB
    U202 (n140 n143 inh_gnd inh_gnds inh_vdd inh_vdds) LVT_invx2_PB4_AFBB
    U217 (n154 n155 inh_gnd inh_gnds inh_vdd inh_vdds) LVT_invx2_PB4_AFBB
    U218 (n154 n156 inh_gnd inh_gnds inh_vdd inh_vdds) LVT_invx2_PB4_AFBB
    U222 (n47 n159 inh_gnd inh_gnds inh_vdd inh_vdds) LVT_invx2_PB4_AFBB
    U61 (n160 n47 inh_gnd inh_gnds inh_vdd inh_vdds) LVT_invx2_PB4_AFBB
    U189 (n643 n331 inh_gnd inh_gnds inh_vdd inh_vdds) LVT_invx2_PB4_AFBB
    U229 (n142 n164 inh_gnd inh_gnds inh_vdd inh_vdds) LVT_invx2_PB4_AFBB
    U64 (n48 n50 inh_gnd inh_gnds inh_vdd inh_vdds) LVT_invx2_PB4_AFBB
    U63 (n48 n49 inh_gnd inh_gnds inh_vdd inh_vdds) LVT_invx2_PB4_AFBB
    U197 (n137 n138 inh_gnd inh_gnds inh_vdd inh_vdds) LVT_invx2_PB4_AFBB
    U198 (n137 n139 inh_gnd inh_gnds inh_vdd inh_vdds) LVT_invx2_PB4_AFBB
    U186 (n555 n273 inh_gnd inh_gnds inh_vdd inh_vdds) LVT_invx2_PB4_AFBB
    U70 (B\<4\> n56 inh_gnd inh_gnds inh_vdd inh_vdds) LVT_invx2_PB4_AFBB
    U3 (n177 n2 inh_gnd inh_gnds inh_vdd inh_vdds) LVT_invx2_PB4_AFBB
    U29 (n177 n22 inh_gnd inh_gnds inh_vdd inh_vdds) LVT_invx2_PB4_AFBB
    U239 (n121 n174 inh_gnd inh_gnds inh_vdd inh_vdds) LVT_invx2_PB4_AFBB
    U165 (n229 n121 inh_gnd inh_gnds inh_vdd inh_vdds) LVT_invx2_PB4_AFBB
    U150 (A\<24\> n112 inh_gnd inh_gnds inh_vdd inh_vdds) LVT_invx2_PB4_AFBB
    U39 (A\<26\> n266 inh_gnd inh_gnds inh_vdd inh_vdds) LVT_invx2_PB4_AFBB
    U147 (A\<23\> n110 inh_gnd inh_gnds inh_vdd inh_vdds) LVT_invx2_PB4_AFBB
    U58 (A\<25\> n45 inh_gnd inh_gnds inh_vdd inh_vdds) LVT_invx2_PB4_AFBB
    U176 (B\<4\> n129 inh_gnd inh_gnds inh_vdd inh_vdds) LVT_invx2_PB4_AFBB
    U234 (n192 n169 inh_gnd inh_gnds inh_vdd inh_vdds) LVT_invx2_PB4_AFBB
    U247 (n212 n253 inh_gnd inh_gnds inh_vdd inh_vdds) LVT_invx2_PB4_AFBB
    U184 (n18 n489 inh_gnd inh_gnds inh_vdd inh_vdds) LVT_invx2_PB4_AFBB
    U80 (A\<4\> n616 inh_gnd inh_gnds inh_vdd inh_vdds) LVT_invx2_PB4_AFBB
    U111 (A\<6\> n84 inh_gnd inh_gnds inh_vdd inh_vdds) LVT_invx2_PB4_AFBB
    U23 (n199 n17 inh_gnd inh_gnds inh_vdd inh_vdds) LVT_invx2_PB4_AFBB
    U77 (A\<3\> n612 inh_gnd inh_gnds inh_vdd inh_vdds) LVT_invx2_PB4_AFBB
    U139 (A\<5\> n591 inh_gnd inh_gnds inh_vdd inh_vdds) LVT_invx2_PB4_AFBB
    U190 (A\<2\> n136 inh_gnd inh_gnds inh_vdd inh_vdds) LVT_invx2_PB4_AFBB
    U41 (A\<0\> n32 inh_gnd inh_gnds inh_vdd inh_vdds) LVT_invx2_PB4_AFBB
    U65 (n193 n51 inh_gnd inh_gnds inh_vdd inh_vdds) LVT_invx2_PB4_AFBB
    U34 (A\<1\> n27 inh_gnd inh_gnds inh_vdd inh_vdds) LVT_invx2_PB4_AFBB
    U75 (A\<3\> n60 inh_gnd inh_gnds inh_vdd inh_vdds) LVT_invx2_PB4_AFBB
    U162 (A\<12\> n120 inh_gnd inh_gnds inh_vdd inh_vdds) LVT_invx2_PB4_AFBB
    U160 (A\<14\> n502 inh_gnd inh_gnds inh_vdd inh_vdds) LVT_invx2_PB4_AFBB
    U121 (A\<11\> n92 inh_gnd inh_gnds inh_vdd inh_vdds) LVT_invx2_PB4_AFBB
    U102 (A\<13\> n78 inh_gnd inh_gnds inh_vdd inh_vdds) LVT_invx2_PB4_AFBB
    U81 (A\<17\> n64 inh_gnd inh_gnds inh_vdd inh_vdds) LVT_invx2_PB4_AFBB
    U85 (A\<15\> n67 inh_gnd inh_gnds inh_vdd inh_vdds) LVT_invx2_PB4_AFBB
    U52 (n328 n40 inh_gnd inh_gnds inh_vdd inh_vdds) LVT_invx2_PB4_AFBB
    U53 (n40 n41 inh_gnd inh_gnds inh_vdd inh_vdds) LVT_invx2_PB4_AFBB
    U144 (A\<16\> n108 inh_gnd inh_gnds inh_vdd inh_vdds) LVT_invx2_PB4_AFBB
    U142 (A\<18\> n438 inh_gnd inh_gnds inh_vdd inh_vdds) LVT_invx2_PB4_AFBB
    U168 (n423 n332 inh_gnd inh_gnds inh_vdd inh_vdds) LVT_invx2_PB4_AFBB
    U245 (n177 n179 inh_gnd inh_gnds inh_vdd inh_vdds) LVT_invx2_PB4_AFBB
    U243 (n253 n177 inh_gnd inh_gnds inh_vdd inh_vdds) LVT_invx2_PB4_AFBB
    U193 (n327 n249 inh_gnd inh_gnds inh_vdd inh_vdds) LVT_invx2_PB4_AFBB
    U156 (A\<19\> n116 inh_gnd inh_gnds inh_vdd inh_vdds) LVT_invx2_PB4_AFBB
    U97 (A\<20\> n75 inh_gnd inh_gnds inh_vdd inh_vdds) LVT_invx2_PB4_AFBB
    U95 (A\<22\> n351 inh_gnd inh_gnds inh_vdd inh_vdds) LVT_invx2_PB4_AFBB
    U152 (A\<21\> n113 inh_gnd inh_gnds inh_vdd inh_vdds) LVT_invx2_PB4_AFBB
    U18 (n181 n12 inh_gnd inh_gnds inh_vdd inh_vdds) LVT_invx2_PB4_AFBB
    U13 (n181 n9 inh_gnd inh_gnds inh_vdd inh_vdds) LVT_invx2_PB4_AFBB
    U112 (A\<6\> n85 inh_gnd inh_gnds inh_vdd inh_vdds) LVT_invx2_PB4_AFBB
    U78 (A\<4\> n62 inh_gnd inh_gnds inh_vdd inh_vdds) LVT_invx2_PB4_AFBB
    U30 (n195 n23 inh_gnd inh_gnds inh_vdd inh_vdds) LVT_invx2_PB4_AFBB
    U137 (A\<5\> n103 inh_gnd inh_gnds inh_vdd inh_vdds) LVT_invx2_PB4_AFBB
    U107 (A\<7\> n590 inh_gnd inh_gnds inh_vdd inh_vdds) LVT_invx2_PB4_AFBB
    U120 (A\<10\> n575 inh_gnd inh_gnds inh_vdd inh_vdds) LVT_invx2_PB4_AFBB
    U161 (A\<12\> n119 inh_gnd inh_gnds inh_vdd inh_vdds) LVT_invx2_PB4_AFBB
    U124 (A\<11\> n549 inh_gnd inh_gnds inh_vdd inh_vdds) LVT_invx2_PB4_AFBB
    U104 (A\<13\> n524 inh_gnd inh_gnds inh_vdd inh_vdds) LVT_invx2_PB4_AFBB
    U143 (A\<16\> n107 inh_gnd inh_gnds inh_vdd inh_vdds) LVT_invx2_PB4_AFBB
    U159 (A\<14\> n118 inh_gnd inh_gnds inh_vdd inh_vdds) LVT_invx2_PB4_AFBB
    U21 (n162 n15 inh_gnd inh_gnds inh_vdd inh_vdds) LVT_invx2_PB4_AFBB
    U226 (n6 n162 inh_gnd inh_gnds inh_vdd inh_vdds) LVT_invx2_PB4_AFBB
    U103 (A\<13\> n79 inh_gnd inh_gnds inh_vdd inh_vdds) LVT_invx2_PB4_AFBB
    U86 (A\<15\> n483 inh_gnd inh_gnds inh_vdd inh_vdds) LVT_invx2_PB4_AFBB
    U205 (n9 n145 inh_gnd inh_gnds inh_vdd inh_vdds) LVT_invx2_PB4_AFBB
    U249 (n145 n182 inh_gnd inh_gnds inh_vdd inh_vdds) LVT_invx2_PB4_AFBB
    U24 (n17 n18 inh_gnd inh_gnds inh_vdd inh_vdds) LVT_invx2_PB4_AFBB
    U20 (n229 n14 inh_gnd inh_gnds inh_vdd inh_vdds) LVT_invx2_PB4_AFBB
    U241 (n14 n176 inh_gnd inh_gnds inh_vdd inh_vdds) LVT_invx2_PB4_AFBB
    U180 (n169 n133 inh_gnd inh_gnds inh_vdd inh_vdds) LVT_invx2_PB4_AFBB
    U231 (n169 n166 inh_gnd inh_gnds inh_vdd inh_vdds) LVT_invx2_PB4_AFBB
    U194 (n354 n270 inh_gnd inh_gnds inh_vdd inh_vdds) LVT_invx2_PB4_AFBB
    U8 (n172 n4 inh_gnd inh_gnds inh_vdd inh_vdds) LVT_invx2_PB4_AFBB
    U16 (n570 n10 inh_gnd inh_gnds inh_vdd inh_vdds) LVT_invx2_PB4_AFBB
    U185 (n570 n357 inh_gnd inh_gnds inh_vdd inh_vdds) LVT_invx2_PB4_AFBB
    U232 (n166 n167 inh_gnd inh_gnds inh_vdd inh_vdds) LVT_invx2_PB4_AFBB
    U135 (n492 n491 inh_gnd inh_gnds inh_vdd inh_vdds) LVT_invx2_PB4_AFBB
    U47 (n35 n36 inh_gnd inh_gnds inh_vdd inh_vdds) LVT_invx2_PB4_AFBB
    U238 (n172 n173 inh_gnd inh_gnds inh_vdd inh_vdds) LVT_invx2_PB4_AFBB
    U32 (n358 n25 inh_gnd inh_gnds inh_vdd inh_vdds) LVT_invx2_PB4_AFBB
    U84 (A\<15\> n66 inh_gnd inh_gnds inh_vdd inh_vdds) LVT_invx2_PB4_AFBB
    U83 (A\<17\> n453 inh_gnd inh_gnds inh_vdd inh_vdds) LVT_invx2_PB4_AFBB
    U45 (n33 n34 inh_gnd inh_gnds inh_vdd inh_vdds) LVT_invx2_PB4_AFBB
    U19 (n391 n13 inh_gnd inh_gnds inh_vdd inh_vdds) LVT_invx2_PB4_AFBB
    U208 (n391 n148 inh_gnd inh_gnds inh_vdd inh_vdds) LVT_invx2_PB4_AFBB
    U210 (n148 n150 inh_gnd inh_gnds inh_vdd inh_vdds) LVT_invx2_PB4_AFBB
    U209 (n148 n149 inh_gnd inh_gnds inh_vdd inh_vdds) LVT_invx2_PB4_AFBB
    U146 (A\<23\> n109 inh_gnd inh_gnds inh_vdd inh_vdds) LVT_invx2_PB4_AFBB
    U60 (A\<25\> n285 inh_gnd inh_gnds inh_vdd inh_vdds) LVT_invx2_PB4_AFBB
    U94 (A\<22\> n73 inh_gnd inh_gnds inh_vdd inh_vdds) LVT_invx2_PB4_AFBB
    U149 (A\<24\> n111 inh_gnd inh_gnds inh_vdd inh_vdds) LVT_invx2_PB4_AFBB
    U72 (B\<4\> n58 inh_gnd inh_gnds inh_vdd inh_vdds) LVT_invx2_PB4_AFBB
    U6 (n185 sll_res\<9\> inh_gnd inh_gnds inh_vdd inh_vdds) LVT_invx2_PB4_AFBB
    U38 (A\<26\> n30 inh_gnd inh_gnds inh_vdd inh_vdds) LVT_invx2_PB4_AFBB
    U90 (A\<28\> n70 inh_gnd inh_gnds inh_vdd inh_vdds) LVT_invx2_PB4_AFBB
    U50 (A\<29\> n39 inh_gnd inh_gnds inh_vdd inh_vdds) LVT_invx2_PB4_AFBB
    U87 (A\<27\> n68 inh_gnd inh_gnds inh_vdd inh_vdds) LVT_invx2_PB4_AFBB
    U68 (B\<2\> n54 inh_gnd inh_gnds inh_vdd inh_vdds) LVT_invx2_PB4_AFBB
    U199 (n372 n140 inh_gnd inh_gnds inh_vdd inh_vdds) LVT_invx2_PB4_AFBB
    U201 (n140 n142 inh_gnd inh_gnds inh_vdd inh_vdds) LVT_invx2_PB4_AFBB
    U242 (n422 n229 inh_gnd inh_gnds inh_vdd inh_vdds) LVT_invx2_PB4_AFBB
    U31 (n23 n24 inh_gnd inh_gnds inh_vdd inh_vdds) LVT_invx2_PB4_AFBB
    U127 (n95 n97 inh_gnd inh_gnds inh_vdd inh_vdds) LVT_invx2_PB4_AFBB
    U126 (n95 n96 inh_gnd inh_gnds inh_vdd inh_vdds) LVT_invx2_PB4_AFBB
    U133 (n96 n254 inh_gnd inh_gnds inh_vdd inh_vdds) LVT_invx2_PB4_AFBB
    U131 (n99 n101 inh_gnd inh_gnds inh_vdd inh_vdds) LVT_invx2_PB4_AFBB
    U164 (n52 n206 inh_gnd inh_gnds inh_vdd inh_vdds) LVT_invx2_PB4_AFBB
    U66 (n51 n52 inh_gnd inh_gnds inh_vdd inh_vdds) LVT_invx2_PB4_AFBB
    U67 (n51 n53 inh_gnd inh_gnds inh_vdd inh_vdds) LVT_invx2_PB4_AFBB
    U244 (n177 n178 inh_gnd inh_gnds inh_vdd inh_vdds) LVT_invx2_PB4_AFBB
    U246 (n177 n180 inh_gnd inh_gnds inh_vdd inh_vdds) LVT_invx2_PB4_AFBB
    U26 (n8 n20 inh_gnd inh_gnds inh_vdd inh_vdds) LVT_invx2_PB4_AFBB
    U237 (n229 n172 inh_gnd inh_gnds inh_vdd inh_vdds) LVT_invx2_PB4_AFBB
    U33 (n25 n26 inh_gnd inh_gnds inh_vdd inh_vdds) LVT_invx2_PB4_AFBB
    U181 (n168 n134 inh_gnd inh_gnds inh_vdd inh_vdds) LVT_invx2_PB4_AFBB
    U235 (n100 n170 inh_gnd inh_gnds inh_vdd inh_vdds) LVT_invx2_PB4_AFBB
    U236 (n100 n171 inh_gnd inh_gnds inh_vdd inh_vdds) LVT_invx2_PB4_AFBB
    U130 (n99 n100 inh_gnd inh_gnds inh_vdd inh_vdds) LVT_invx2_PB4_AFBB
    U129 (n102 n99 inh_gnd inh_gnds inh_vdd inh_vdds) LVT_invx2_PB4_AFBB
    U132 (n194 n102 inh_gnd inh_gnds inh_vdd inh_vdds) LVT_invx2_PB4_AFBB
    U628 (B\<3\> n448 n596 inh_gnd inh_gnds inh_vdd inh_vdds) LVT_NADN2x1_PB4_AFBB
    U620 (n123 n518 n597 inh_gnd inh_gnds inh_vdd inh_vdds) LVT_NADN2x1_PB4_AFBB
    U619 (n596 n597 n584 inh_gnd inh_gnds inh_vdd inh_vdds) LVT_NADN2x1_PB4_AFBB
    U315 (n274 n275 sll_res\<28\> inh_gnd inh_gnds inh_vdd inh_vdds) LVT_NADN2x1_PB4_AFBB
    U326 (n135 n288 n278 inh_gnd inh_gnds inh_vdd inh_vdds) LVT_NADN2x1_PB4_AFBB
    U318 (n280 n170 n279 inh_gnd inh_gnds inh_vdd inh_vdds) LVT_NADN2x1_PB4_AFBB
    U319 (n281 n282 n280 inh_gnd inh_gnds inh_vdd inh_vdds) LVT_NADN2x1_PB4_AFBB
    U317 (n278 n279 n277 inh_gnd inh_gnds inh_vdd inh_vdds) LVT_NADN2x1_PB4_AFBB
    U462 (n445 n446 n444 inh_gnd inh_gnds inh_vdd inh_vdds) LVT_NADN2x1_PB4_AFBB
    U465 (n171 n380 n445 inh_gnd inh_gnds inh_vdd inh_vdds) LVT_NADN2x1_PB4_AFBB
    U393 (n171 n288 n363 inh_gnd inh_gnds inh_vdd inh_vdds) LVT_NADN2x1_PB4_AFBB
    U463 (n447 B\<4\> n446 inh_gnd inh_gnds inh_vdd inh_vdds) LVT_NADN2x1_PB4_AFBB
    U460 (n441 n442 sll_res\<20\> inh_gnd inh_gnds inh_vdd inh_vdds) LVT_NADN2x1_PB4_AFBB
    U264 (n55 n128 n204 inh_gnd inh_gnds inh_vdd inh_vdds) LVT_NADN2x1_PB4_AFBB
    U466 (n449 n450 n380 inh_gnd inh_gnds inh_vdd inh_vdds) LVT_NADN2x1_PB4_AFBB
    U384 (n359 n360 sll_res\<24\> inh_gnd inh_gnds inh_vdd inh_vdds) LVT_NADN2x1_PB4_AFBB
    U387 (B\<4\> n189 n364 inh_gnd inh_gnds inh_vdd inh_vdds) LVT_NADN2x1_PB4_AFBB
    U386 (n363 n364 n362 inh_gnd inh_gnds inh_vdd inh_vdds) LVT_NADN2x1_PB4_AFBB
    U394 (n373 n374 n288 inh_gnd inh_gnds inh_vdd inh_vdds) LVT_NADN2x1_PB4_AFBB
    U621 (n598 n599 n518 inh_gnd inh_gnds inh_vdd inh_vdds) LVT_NADN2x1_PB4_AFBB
    U526 (n507 n508 sll_res\<16\> inh_gnd inh_gnds inh_vdd inh_vdds) LVT_NADN2x1_PB4_AFBB
    U539 (n520 n521 n519 inh_gnd inh_gnds inh_vdd inh_vdds) LVT_NADN2x1_PB4_AFBB
    U630 (B\<2\> n513 n606 inh_gnd inh_gnds inh_vdd inh_vdds) LVT_NADN2x1_PB4_AFBB
    U629 (n605 n606 n448 inh_gnd inh_gnds inh_vdd inh_vdds) LVT_NADN2x1_PB4_AFBB
    U631 (n607 n515 n605 inh_gnd inh_gnds inh_vdd inh_vdds) LVT_NADN2x1_PB4_AFBB
    U588 (B\<3\> B\<2\> n514 inh_gnd inh_gnds inh_vdd inh_vdds) LVT_NADN2x1_PB4_AFBB
    U529 (n513 n149 n512 inh_gnd inh_gnds inh_vdd inh_vdds) LVT_NADN2x1_PB4_AFBB
    U531 (n43 n14 n511 inh_gnd inh_gnds inh_vdd inh_vdds) LVT_NADN2x1_PB4_AFBB
    U528 (n511 n512 n510 inh_gnd inh_gnds inh_vdd inh_vdds) LVT_NADN2x1_PB4_AFBB
    U388 (n366 n365 n189 inh_gnd inh_gnds inh_vdd inh_vdds) LVT_NADN2x1_PB4_AFBB
    U389 (n43 n154 n366 inh_gnd inh_gnds inh_vdd inh_vdds) LVT_NADN2x1_PB4_AFBB
    U632 (n608 n609 n515 inh_gnd inh_gnds inh_vdd inh_vdds) LVT_NADN2x1_PB4_AFBB
    U612 (n586 n587 n368 inh_gnd inh_gnds inh_vdd inh_vdds) LVT_NADN2x1_PB4_AFBB
    U253 (n57 n189 n188 inh_gnd inh_gnds inh_vdd inh_vdds) LVT_NADN2x1_PB4_AFBB
    U530 (B\<4\> n154 n497 inh_gnd inh_gnds inh_vdd inh_vdds) LVT_NADN2x1_PB4_AFBB
    U451 (n434 n435 n354 inh_gnd inh_gnds inh_vdd inh_vdds) LVT_NADN2x1_PB4_AFBB
    U582 (n146 A\<8\> n563 inh_gnd inh_gnds inh_vdd inh_vdds) LVT_NADN2x1_PB4_AFBB
    U583 (A\<6\> n162 n562 inh_gnd inh_gnds inh_vdd inh_vdds) LVT_NADN2x1_PB4_AFBB
    U581 (n562 n563 n561 inh_gnd inh_gnds inh_vdd inh_vdds) LVT_NADN2x1_PB4_AFBB
    U586 (A\<7\> n152 n564 inh_gnd inh_gnds inh_vdd inh_vdds) LVT_NADN2x1_PB4_AFBB
    U585 (n131 A\<9\> n565 inh_gnd inh_gnds inh_vdd inh_vdds) LVT_NADN2x1_PB4_AFBB
    U584 (n564 n565 n560 inh_gnd inh_gnds inh_vdd inh_vdds) LVT_NADN2x1_PB4_AFBB
    U608 (A\<2\> n162 n582 inh_gnd inh_gnds inh_vdd inh_vdds) LVT_NADN2x1_PB4_AFBB
    U607 (A\<3\> n152 n583 inh_gnd inh_gnds inh_vdd inh_vdds) LVT_NADN2x1_PB4_AFBB
    U606 (n582 n583 n578 inh_gnd inh_gnds inh_vdd inh_vdds) LVT_NADN2x1_PB4_AFBB
    U604 (A\<5\> n131 n581 inh_gnd inh_gnds inh_vdd inh_vdds) LVT_NADN2x1_PB4_AFBB
    U605 (n145 A\<4\> n580 inh_gnd inh_gnds inh_vdd inh_vdds) LVT_NADN2x1_PB4_AFBB
    U603 (n580 n581 n579 inh_gnd inh_gnds inh_vdd inh_vdds) LVT_NADN2x1_PB4_AFBB
    U590 (A\<0\> n145 n567 inh_gnd inh_gnds inh_vdd inh_vdds) LVT_NADN2x1_PB4_AFBB
    U591 (A\<1\> n132 n566 inh_gnd inh_gnds inh_vdd inh_vdds) LVT_NADN2x1_PB4_AFBB
    U589 (n566 n567 n202 inh_gnd inh_gnds inh_vdd inh_vdds) LVT_NADN2x1_PB4_AFBB
    U556 (A\<12\> n162 n536 inh_gnd inh_gnds inh_vdd inh_vdds) LVT_NADN2x1_PB4_AFBB
    U554 (n536 n537 n532 inh_gnd inh_gnds inh_vdd inh_vdds) LVT_NADN2x1_PB4_AFBB
    U555 (A\<13\> n153 n537 inh_gnd inh_gnds inh_vdd inh_vdds) LVT_NADN2x1_PB4_AFBB
    U551 (n534 n535 n533 inh_gnd inh_gnds inh_vdd inh_vdds) LVT_NADN2x1_PB4_AFBB
    U552 (n131 A\<15\> n535 inh_gnd inh_gnds inh_vdd inh_vdds) LVT_NADN2x1_PB4_AFBB
    U553 (n147 A\<14\> n534 inh_gnd inh_gnds inh_vdd inh_vdds) LVT_NADN2x1_PB4_AFBB
    U489 (A\<16\> n162 n468 inh_gnd inh_gnds inh_vdd inh_vdds) LVT_NADN2x1_PB4_AFBB
    U488 (A\<17\> n152 n469 inh_gnd inh_gnds inh_vdd inh_vdds) LVT_NADN2x1_PB4_AFBB
    U487 (n468 n469 n464 inh_gnd inh_gnds inh_vdd inh_vdds) LVT_NADN2x1_PB4_AFBB
    U486 (n145 A\<18\> n466 inh_gnd inh_gnds inh_vdd inh_vdds) LVT_NADN2x1_PB4_AFBB
    U485 (A\<19\> n21 n467 inh_gnd inh_gnds inh_vdd inh_vdds) LVT_NADN2x1_PB4_AFBB
    U484 (n466 n467 n465 inh_gnd inh_gnds inh_vdd inh_vdds) LVT_NADN2x1_PB4_AFBB
    U670 (A\<2\> n21 n647 inh_gnd inh_gnds inh_vdd inh_vdds) LVT_NADN2x1_PB4_AFBB
    U669 (n647 n646 n198 inh_gnd inh_gnds inh_vdd inh_vdds) LVT_NADN2x1_PB4_AFBB
    U659 (n637 n638 n636 inh_gnd inh_gnds inh_vdd inh_vdds) LVT_NADN2x1_PB4_AFBB
    U416 (n132 A\<23\> n397 inh_gnd inh_gnds inh_vdd inh_vdds) LVT_NADN2x1_PB4_AFBB
    U415 (n396 n397 n392 inh_gnd inh_gnds inh_vdd inh_vdds) LVT_NADN2x1_PB4_AFBB
    U417 (A\<21\> n19 n396 inh_gnd inh_gnds inh_vdd inh_vdds) LVT_NADN2x1_PB4_AFBB
    U291 (n132 A\<30\> n246 inh_gnd inh_gnds inh_vdd inh_vdds) LVT_NADN2x1_PB4_AFBB
    U338 (n147 A\<26\> n305 inh_gnd inh_gnds inh_vdd inh_vdds) LVT_NADN2x1_PB4_AFBB
    U339 (A\<24\> n162 n304 inh_gnd inh_gnds inh_vdd inh_vdds) LVT_NADN2x1_PB4_AFBB
    U337 (n304 n305 n303 inh_gnd inh_gnds inh_vdd inh_vdds) LVT_NADN2x1_PB4_AFBB
    U342 (A\<25\> n152 n306 inh_gnd inh_gnds inh_vdd inh_vdds) LVT_NADN2x1_PB4_AFBB
    U276 (A\<29\> n152 n224 inh_gnd inh_gnds inh_vdd inh_vdds) LVT_NADN2x1_PB4_AFBB
    U341 (A\<27\> n131 n307 inh_gnd inh_gnds inh_vdd inh_vdds) LVT_NADN2x1_PB4_AFBB
    U277 (A\<31\> n131 n223 inh_gnd inh_gnds inh_vdd inh_vdds) LVT_NADN2x1_PB4_AFBB
    U340 (n306 n307 n302 inh_gnd inh_gnds inh_vdd inh_vdds) LVT_NADN2x1_PB4_AFBB
    U275 (n223 n224 n222 inh_gnd inh_gnds inh_vdd inh_vdds) LVT_NADN2x1_PB4_AFBB
    U279 (A\<28\> n162 n227 inh_gnd inh_gnds inh_vdd inh_vdds) LVT_NADN2x1_PB4_AFBB
    U280 (A\<30\> n146 n226 inh_gnd inh_gnds inh_vdd inh_vdds) LVT_NADN2x1_PB4_AFBB
    U413 (n146 A\<22\> n395 inh_gnd inh_gnds inh_vdd inh_vdds) LVT_NADN2x1_PB4_AFBB
    U278 (n226 n227 n221 inh_gnd inh_gnds inh_vdd inh_vdds) LVT_NADN2x1_PB4_AFBB
    U414 (A\<20\> n162 n394 inh_gnd inh_gnds inh_vdd inh_vdds) LVT_NADN2x1_PB4_AFBB
    U412 (n394 n395 n393 inh_gnd inh_gnds inh_vdd inh_vdds) LVT_NADN2x1_PB4_AFBB
    U335 (n170 n217 n298 inh_gnd inh_gnds inh_vdd inh_vdds) LVT_NADN2x1_PB4_AFBB
    U271 (n133 n217 n216 inh_gnd inh_gnds inh_vdd inh_vdds) LVT_NADN2x1_PB4_AFBB
    U334 (n300 n133 n299 inh_gnd inh_gnds inh_vdd inh_vdds) LVT_NADN2x1_PB4_AFBB
    U270 (n215 n216 n208 inh_gnd inh_gnds inh_vdd inh_vdds) LVT_NADN2x1_PB4_AFBB
    U333 (n298 n299 n297 inh_gnd inh_gnds inh_vdd inh_vdds) LVT_NADN2x1_PB4_AFBB
    U405 (n384 n385 sll_res\<23\> inh_gnd inh_gnds inh_vdd inh_vdds) LVT_NADN2x1_PB4_AFBB
    U407 (n388 n389 n387 inh_gnd inh_gnds inh_vdd inh_vdds) LVT_NADN2x1_PB4_AFBB
    U409 (n150 n24 n388 inh_gnd inh_gnds inh_vdd inh_vdds) LVT_NADN2x1_PB4_AFBB
    U420 (n134 n213 n401 inh_gnd inh_gnds inh_vdd inh_vdds) LVT_NADN2x1_PB4_AFBB
    U419 (n400 n401 n399 inh_gnd inh_gnds inh_vdd inh_vdds) LVT_NADN2x1_PB4_AFBB
    U482 (n213 n99 n462 inh_gnd inh_gnds inh_vdd inh_vdds) LVT_NADN2x1_PB4_AFBB
    U480 (n462 n463 n461 inh_gnd inh_gnds inh_vdd inh_vdds) LVT_NADN2x1_PB4_AFBB
    U481 (n149 n53 n463 inh_gnd inh_gnds inh_vdd inh_vdds) LVT_NADN2x1_PB4_AFBB
    U408 (n390 n53 n389 inh_gnd inh_gnds inh_vdd inh_vdds) LVT_NADN2x1_PB4_AFBB
    U331 (n294 n295 sll_res\<27\> inh_gnd inh_gnds inh_vdd inh_vdds) LVT_NADN2x1_PB4_AFBB
    U640 (n620 n619 n618 inh_gnd inh_gnds inh_vdd inh_vdds) LVT_NADN2x1_PB4_AFBB
    U641 (n164 n52 n620 inh_gnd inh_gnds inh_vdd inh_vdds) LVT_NADN2x1_PB4_AFBB
    U368 (n34 n164 n340 inh_gnd inh_gnds inh_vdd inh_vdds) LVT_NADN2x1_PB4_AFBB
    U367 (n340 n339 n187 inh_gnd inh_gnds inh_vdd inh_vdds) LVT_NADN2x1_PB4_AFBB
    U269 (B\<4\> n214 n210 inh_gnd inh_gnds inh_vdd inh_vdds) LVT_NADN2x1_PB4_AFBB
    U268 (n122 n213 n211 inh_gnd inh_gnds inh_vdd inh_vdds) LVT_NADN2x1_PB4_AFBB
    U267 (n210 n211 n209 inh_gnd inh_gnds inh_vdd inh_vdds) LVT_NADN2x1_PB4_AFBB
    U478 (n458 n459 sll_res\<19\> inh_gnd inh_gnds inh_vdd inh_vdds) LVT_NADN2x1_PB4_AFBB
    U547 (n528 n529 n214 inh_gnd inh_gnds inh_vdd inh_vdds) LVT_NADN2x1_PB4_AFBB
    U677 (B\<2\> n205 n344 inh_gnd inh_gnds inh_vdd inh_vdds) LVT_NADN2x1_PB4_AFBB
    U689 (B\<0\> n663 n241 inh_gnd inh_gnds inh_vdd inh_vdds) LVT_NADN2x1_PB4_AFBB
    U546 (n59 n214 n527 inh_gnd inh_gnds inh_vdd inh_vdds) LVT_NADN2x1_PB4_AFBB
    U686 (n659 n660 n658 inh_gnd inh_gnds inh_vdd inh_vdds) LVT_NADN2x1_PB4_AFBB
    U285 (n236 n170 n235 inh_gnd inh_gnds inh_vdd inh_vdds) LVT_NADN2x1_PB4_AFBB
    U284 (n234 n235 n233 inh_gnd inh_gnds inh_vdd inh_vdds) LVT_NADN2x1_PB4_AFBB
    U293 (n135 n248 n234 inh_gnd inh_gnds inh_vdd inh_vdds) LVT_NADN2x1_PB4_AFBB
    U286 (n237 n238 n236 inh_gnd inh_gnds inh_vdd inh_vdds) LVT_NADN2x1_PB4_AFBB
    U282 (n230 n231 sll_res\<30\> inh_gnd inh_gnds inh_vdd inh_vdds) LVT_NADN2x1_PB4_AFBB
    U562 (n541 n542 n540 inh_gnd inh_gnds inh_vdd inh_vdds) LVT_NADN2x1_PB4_AFBB
    U668 (n96 n164 n645 inh_gnd inh_gnds inh_vdd inh_vdds) LVT_NADN2x1_PB4_AFBB
    U667 (n645 n644 n643 inh_gnd inh_gnds inh_vdd inh_vdds) LVT_NADN2x1_PB4_AFBB
    U577 (n556 n557 n555 inh_gnd inh_gnds inh_vdd inh_vdds) LVT_NADN2x1_PB4_AFBB
    U347 (n313 n314 sll_res\<26\> inh_gnd inh_gnds inh_vdd inh_vdds) LVT_NADN2x1_PB4_AFBB
    U350 (n99 n248 n318 inh_gnd inh_gnds inh_vdd inh_vdds) LVT_NADN2x1_PB4_AFBB
    U358 (n166 n327 n317 inh_gnd inh_gnds inh_vdd inh_vdds) LVT_NADN2x1_PB4_AFBB
    U349 (n317 n318 n316 inh_gnd inh_gnds inh_vdd inh_vdds) LVT_NADN2x1_PB4_AFBB
    U351 (n319 n320 n248 inh_gnd inh_gnds inh_vdd inh_vdds) LVT_NADN2x1_PB4_AFBB
    U299 (n255 n256 sll_res\<29\> inh_gnd inh_gnds inh_vdd inh_vdds) LVT_NADN2x1_PB4_AFBB
    U301 (n259 n260 n258 inh_gnd inh_gnds inh_vdd inh_vdds) LVT_NADN2x1_PB4_AFBB
    U678 (n652 n653 n199 inh_gnd inh_gnds inh_vdd inh_vdds) LVT_NADN2x1_PB4_AFBB
    U642 (n621 n622 n193 inh_gnd inh_gnds inh_vdd inh_vdds) LVT_NADN2x1_PB4_AFBB
    U565 (n545 n546 n423 inh_gnd inh_gnds inh_vdd inh_vdds) LVT_NADN2x1_PB4_AFBB
    U499 (n479 n480 n328 inh_gnd inh_gnds inh_vdd inh_vdds) LVT_NADN2x1_PB4_AFBB
    U494 (n473 n474 sll_res\<18\> inh_gnd inh_gnds inh_vdd inh_vdds) LVT_NADN2x1_PB4_AFBB
    U498 (n41 n170 n477 inh_gnd inh_gnds inh_vdd inh_vdds) LVT_NADN2x1_PB4_AFBB
    U497 (n150 n97 n478 inh_gnd inh_gnds inh_vdd inh_vdds) LVT_NADN2x1_PB4_AFBB
    U496 (n477 n478 n476 inh_gnd inh_gnds inh_vdd inh_vdds) LVT_NADN2x1_PB4_AFBB
    U439 (n14 n423 n420 inh_gnd inh_gnds inh_vdd inh_vdds) LVT_NADN2x1_PB4_AFBB
    U437 (n420 n421 n419 inh_gnd inh_gnds inh_vdd inh_vdds) LVT_NADN2x1_PB4_AFBB
    U438 (n41 n134 n421 inh_gnd inh_gnds inh_vdd inh_vdds) LVT_NADN2x1_PB4_AFBB
    U423 (n404 n405 sll_res\<22\> inh_gnd inh_gnds inh_vdd inh_vdds) LVT_NADN2x1_PB4_AFBB
    U429 (n410 n411 n327 inh_gnd inh_gnds inh_vdd inh_vdds) LVT_NADN2x1_PB4_AFBB
    U651 (n630 n631 n195 inh_gnd inh_gnds inh_vdd inh_vdds) LVT_NADN2x1_PB4_AFBB
    U594 (n571 n572 n570 inh_gnd inh_gnds inh_vdd inh_vdds) LVT_NADN2x1_PB4_AFBB
    U10 (B\<1\> B\<0\> n6 inh_gnd inh_gnds inh_vdd inh_vdds) LVT_NADN2x1_PB4_AFBB
    U363 (n333 n334 sll_res\<25\> inh_gnd inh_gnds inh_vdd inh_vdds) LVT_NADN2x1_PB4_AFBB
    U450 (n171 n354 n433 inh_gnd inh_gnds inh_vdd inh_vdds) LVT_NADN2x1_PB4_AFBB
    U449 (n432 n433 n431 inh_gnd inh_gnds inh_vdd inh_vdds) LVT_NADN2x1_PB4_AFBB
    U458 (n133 n26 n432 inh_gnd inh_gnds inh_vdd inh_vdds) LVT_NADN2x1_PB4_AFBB
    U441 (n424 n425 sll_res\<21\> inh_gnd inh_gnds inh_vdd inh_vdds) LVT_NADN2x1_PB4_AFBB
    U510 (n491 n490 sll_res\<17\> inh_gnd inh_gnds inh_vdd inh_vdds) LVT_NADN2x1_PB4_AFBB
    U515 (n26 n170 n493 inh_gnd inh_gnds inh_vdd inh_vdds) LVT_NADN2x1_PB4_AFBB
    U511 (n493 n494 n492 inh_gnd inh_gnds inh_vdd inh_vdds) LVT_NADN2x1_PB4_AFBB
    U516 (n498 n499 n358 inh_gnd inh_gnds inh_vdd inh_vdds) LVT_NADN2x1_PB4_AFBB
    U446 (n35 n150 n428 inh_gnd inh_gnds inh_vdd inh_vdds) LVT_NADN2x1_PB4_AFBB
    U444 (n34 n390 n429 inh_gnd inh_gnds inh_vdd inh_vdds) LVT_NADN2x1_PB4_AFBB
    U426 (n390 n97 n409 inh_gnd inh_gnds inh_vdd inh_vdds) LVT_NADN2x1_PB4_AFBB
    U443 (n428 n429 n427 inh_gnd inh_gnds inh_vdd inh_vdds) LVT_NADN2x1_PB4_AFBB
    U427 (n149 n18 n408 inh_gnd inh_gnds inh_vdd inh_vdds) LVT_NADN2x1_PB4_AFBB
    U259 (n171 n18 n196 inh_gnd inh_gnds inh_vdd inh_vdds) LVT_NADN2x1_PB4_AFBB
    U257 (n196 n197 sll_res\<6\> inh_gnd inh_gnds inh_vdd inh_vdds) LVT_NADN2x1_PB4_AFBB
    U258 (n134 n97 n197 inh_gnd inh_gnds inh_vdd inh_vdds) LVT_NADN2x1_PB4_AFBB
    U425 (n408 n409 n407 inh_gnd inh_gnds inh_vdd inh_vdds) LVT_NADN2x1_PB4_AFBB
    U372 (n171 n269 n337 inh_gnd inh_gnds inh_vdd inh_vdds) LVT_NADN2x1_PB4_AFBB
    U366 (B\<4\> n187 n338 inh_gnd inh_gnds inh_vdd inh_vdds) LVT_NADN2x1_PB4_AFBB
    U365 (n337 n338 n336 inh_gnd inh_gnds inh_vdd inh_vdds) LVT_NADN2x1_PB4_AFBB
    U373 (n347 n348 n269 inh_gnd inh_gnds inh_vdd inh_vdds) LVT_NADN2x1_PB4_AFBB
    U252 (n58 n187 n185 inh_gnd inh_gnds inh_vdd inh_vdds) LVT_NADN2x1_PB4_AFBB
    U302 (n261 n194 n260 inh_gnd inh_gnds inh_vdd inh_vdds) LVT_NADN2x1_PB4_AFBB
    U303 (n262 n263 n261 inh_gnd inh_gnds inh_vdd inh_vdds) LVT_NADN2x1_PB4_AFBB
    U674 (B\<3\> n54 n372 inh_gnd inh_gnds inh_vdd inh_vdds) LVT_NADN2x1_PB4_AFBB
    U256 (n194 n24 n190 inh_gnd inh_gnds inh_vdd inh_vdds) LVT_NADN2x1_PB4_AFBB
    U254 (n190 n191 sll_res\<7\> inh_gnd inh_gnds inh_vdd inh_vdds) LVT_NADN2x1_PB4_AFBB
    U262 (n170 n35 n200 inh_gnd inh_gnds inh_vdd inh_vdds) LVT_NADN2x1_PB4_AFBB
    U261 (n134 n34 n201 inh_gnd inh_gnds inh_vdd inh_vdds) LVT_NADN2x1_PB4_AFBB
    U260 (n200 n201 sll_res\<5\> inh_gnd inh_gnds inh_vdd inh_vdds) LVT_NADN2x1_PB4_AFBB
    U255 (n166 n53 n191 inh_gnd inh_gnds inh_vdd inh_vdds) LVT_NADN2x1_PB4_AFBB
    U310 (n134 n269 n259 inh_gnd inh_gnds inh_vdd inh_vdds) LVT_NADN2x1_PB4_AFBB
    U167 (B\<2\> B\<3\> n123 inh_gnd inh_gnds inh_vdd inh_vdds) LVT_NOR2x1_PB4_AFBB
    U610 (n584 n585 n292 inh_gnd inh_gnds inh_vdd inh_vdds) LVT_NOR2x1_PB4_AFBB
    U611 (n42 n158 n585 inh_gnd inh_gnds inh_vdd inh_vdds) LVT_NOR2x1_PB4_AFBB
    U476 (n42 n3 n456 inh_gnd inh_gnds inh_vdd inh_vdds) LVT_NOR2x1_PB4_AFBB
    U329 (n292 n127 n291 inh_gnd inh_gnds inh_vdd inh_vdds) LVT_NOR2x1_PB4_AFBB
    U316 (n276 n277 n275 inh_gnd inh_gnds inh_vdd inh_vdds) LVT_NOR2x1_PB4_AFBB
    U327 (n4 n289 n276 inh_gnd inh_gnds inh_vdd inh_vdds) LVT_NOR2x1_PB4_AFBB
    U330 (n293 n22 n290 inh_gnd inh_gnds inh_vdd inh_vdds) LVT_NOR2x1_PB4_AFBB
    U328 (n290 n291 n274 inh_gnd inh_gnds inh_vdd inh_vdds) LVT_NOR2x1_PB4_AFBB
    U325 (n151 n29 n286 inh_gnd inh_gnds inh_vdd inh_vdds) LVT_NOR2x1_PB4_AFBB
    U324 (n20 n247 n287 inh_gnd inh_gnds inh_vdd inh_vdds) LVT_NOR2x1_PB4_AFBB
    U323 (n287 n286 n281 inh_gnd inh_gnds inh_vdd inh_vdds) LVT_NOR2x1_PB4_AFBB
    U322 (n15 n46 n283 inh_gnd inh_gnds inh_vdd inh_vdds) LVT_NOR2x1_PB4_AFBB
    U321 (n12 n243 n284 inh_gnd inh_gnds inh_vdd inh_vdds) LVT_NOR2x1_PB4_AFBB
    U320 (n283 n284 n282 inh_gnd inh_gnds inh_vdd inh_vdds) LVT_NOR2x1_PB4_AFBB
    U464 (B\<3\> n203 n447 inh_gnd inh_gnds inh_vdd inh_vdds) LVT_NOR2x1_PB4_AFBB
    U473 (n383 n175 n443 inh_gnd inh_gnds inh_vdd inh_vdds) LVT_NOR2x1_PB4_AFBB
    U461 (n443 n444 n442 inh_gnd inh_gnds inh_vdd inh_vdds) LVT_NOR2x1_PB4_AFBB
    U474 (n456 n457 n441 inh_gnd inh_gnds inh_vdd inh_vdds) LVT_NOR2x1_PB4_AFBB
    U475 (n169 n11 n457 inh_gnd inh_gnds inh_vdd inh_vdds) LVT_NOR2x1_PB4_AFBB
    U263 (n204 n203 sll_res\<4\> inh_gnd inh_gnds inh_vdd inh_vdds) LVT_NOR2x1_PB4_AFBB
    U467 (n451 n452 n450 inh_gnd inh_gnds inh_vdd inh_vdds) LVT_NOR2x1_PB4_AFBB
    U469 (n98 n65 n451 inh_gnd inh_gnds inh_vdd inh_vdds) LVT_NOR2x1_PB4_AFBB
    U472 (n151 n105 n454 inh_gnd inh_gnds inh_vdd inh_vdds) LVT_NOR2x1_PB4_AFBB
    U471 (n20 n417 n455 inh_gnd inh_gnds inh_vdd inh_vdds) LVT_NOR2x1_PB4_AFBB
    U470 (n454 n455 n449 inh_gnd inh_gnds inh_vdd inh_vdds) LVT_NOR2x1_PB4_AFBB
    U468 (n12 n414 n452 inh_gnd inh_gnds inh_vdd inh_vdds) LVT_NOR2x1_PB4_AFBB
    U401 (n167 n289 n361 inh_gnd inh_gnds inh_vdd inh_vdds) LVT_NOR2x1_PB4_AFBB
    U536 (n167 n383 n517 inh_gnd inh_gnds inh_vdd inh_vdds) LVT_NOR2x1_PB4_AFBB
    U385 (n362 n361 n360 inh_gnd inh_gnds inh_vdd inh_vdds) LVT_NOR2x1_PB4_AFBB
    U404 (n175 n293 n381 inh_gnd inh_gnds inh_vdd inh_vdds) LVT_NOR2x1_PB4_AFBB
    U403 (n383 n2 n382 inh_gnd inh_gnds inh_vdd inh_vdds) LVT_NOR2x1_PB4_AFBB
    U402 (n381 n382 n359 inh_gnd inh_gnds inh_vdd inh_vdds) LVT_NOR2x1_PB4_AFBB
    U400 (n151 n72 n378 inh_gnd inh_gnds inh_vdd inh_vdds) LVT_NOR2x1_PB4_AFBB
    U399 (n20 n326 n379 inh_gnd inh_gnds inh_vdd inh_vdds) LVT_NOR2x1_PB4_AFBB
    U398 (n379 n378 n373 inh_gnd inh_gnds inh_vdd inh_vdds) LVT_NOR2x1_PB4_AFBB
    U397 (n15 n114 n375 inh_gnd inh_gnds inh_vdd inh_vdds) LVT_NOR2x1_PB4_AFBB
    U396 (n184 n323 n376 inh_gnd inh_gnds inh_vdd inh_vdds) LVT_NOR2x1_PB4_AFBB
    U395 (n375 n376 n374 inh_gnd inh_gnds inh_vdd inh_vdds) LVT_NOR2x1_PB4_AFBB
    U627 (n151 n90 n603 inh_gnd inh_gnds inh_vdd inh_vdds) LVT_NOR2x1_PB4_AFBB
    U626 (n20 n552 n604 inh_gnd inh_gnds inh_vdd inh_vdds) LVT_NOR2x1_PB4_AFBB
    U625 (n603 n604 n598 inh_gnd inh_gnds inh_vdd inh_vdds) LVT_NOR2x1_PB4_AFBB
    U624 (n15 n77 n600 inh_gnd inh_gnds inh_vdd inh_vdds) LVT_NOR2x1_PB4_AFBB
    U623 (n241 n94 n601 inh_gnd inh_gnds inh_vdd inh_vdds) LVT_NOR2x1_PB4_AFBB
    U622 (n601 n600 n599 inh_gnd inh_gnds inh_vdd inh_vdds) LVT_NOR2x1_PB4_AFBB
    U538 (n100 n11 n516 inh_gnd inh_gnds inh_vdd inh_vdds) LVT_NOR2x1_PB4_AFBB
    U535 (n516 n517 n507 inh_gnd inh_gnds inh_vdd inh_vdds) LVT_NOR2x1_PB4_AFBB
    U545 (n151 n117 n525 inh_gnd inh_gnds inh_vdd inh_vdds) LVT_NOR2x1_PB4_AFBB
    U544 (n20 n486 n526 inh_gnd inh_gnds inh_vdd inh_vdds) LVT_NOR2x1_PB4_AFBB
    U543 (n525 n526 n520 inh_gnd inh_gnds inh_vdd inh_vdds) LVT_NOR2x1_PB4_AFBB
    U698 (n20 n625 n513 inh_gnd inh_gnds inh_vdd inh_vdds) LVT_NOR2x1_PB4_AFBB
    U697 (B\<2\> B\<3\> n367 inh_gnd inh_gnds inh_vdd inh_vdds) LVT_NOR2x1_PB4_AFBB
    U696 (n346 B\<4\> n194 inh_gnd inh_gnds inh_vdd inh_vdds) LVT_NOR2x1_PB4_AFBB
    U666 (B\<4\> n331 sll_res\<10\> inh_gnd inh_gnds inh_vdd inh_vdds) LVT_NOR2x1_PB4_AFBB
    U639 (B\<4\> n311 sll_res\<11\> inh_gnd inh_gnds inh_vdd inh_vdds) LVT_NOR2x1_PB4_AFBB
    U609 (B\<4\> n292 sll_res\<12\> inh_gnd inh_gnds inh_vdd inh_vdds) LVT_NOR2x1_PB4_AFBB
    U576 (B\<4\> n273 sll_res\<13\> inh_gnd inh_gnds inh_vdd inh_vdds) LVT_NOR2x1_PB4_AFBB
    U561 (B\<4\> n252 sll_res\<14\> inh_gnd inh_gnds inh_vdd inh_vdds) LVT_NOR2x1_PB4_AFBB
    U527 (n509 n510 n508 inh_gnd inh_gnds inh_vdd inh_vdds) LVT_NOR2x1_PB4_AFBB
    U533 (n178 n371 n509 inh_gnd inh_gnds inh_vdd inh_vdds) LVT_NOR2x1_PB4_AFBB
    U392 (n165 n143 n369 inh_gnd inh_gnds inh_vdd inh_vdds) LVT_NOR2x1_PB4_AFBB
    U391 (n158 n371 n370 inh_gnd inh_gnds inh_vdd inh_vdds) LVT_NOR2x1_PB4_AFBB
    U390 (n370 n369 n365 inh_gnd inh_gnds inh_vdd inh_vdds) LVT_NOR2x1_PB4_AFBB
    U633 (n610 n611 n609 inh_gnd inh_gnds inh_vdd inh_vdds) LVT_NOR2x1_PB4_AFBB
    U638 (n151 n617 n614 inh_gnd inh_gnds inh_vdd inh_vdds) LVT_NOR2x1_PB4_AFBB
    U637 (n20 n63 n615 inh_gnd inh_gnds inh_vdd inh_vdds) LVT_NOR2x1_PB4_AFBB
    U636 (n614 n615 n608 inh_gnd inh_gnds inh_vdd inh_vdds) LVT_NOR2x1_PB4_AFBB
    U635 (n163 n28 n610 inh_gnd inh_gnds inh_vdd inh_vdds) LVT_NOR2x1_PB4_AFBB
    U634 (n124 n61 n611 inh_gnd inh_gnds inh_vdd inh_vdds) LVT_NOR2x1_PB4_AFBB
    U618 (n151 n595 n592 inh_gnd inh_gnds inh_vdd inh_vdds) LVT_NOR2x1_PB4_AFBB
    U617 (n20 n82 n593 inh_gnd inh_gnds inh_vdd inh_vdds) LVT_NOR2x1_PB4_AFBB
    U616 (n592 n593 n586 inh_gnd inh_gnds inh_vdd inh_vdds) LVT_NOR2x1_PB4_AFBB
    U615 (n126 n104 n588 inh_gnd inh_gnds inh_vdd inh_vdds) LVT_NOR2x1_PB4_AFBB
    U614 (n184 n81 n589 inh_gnd inh_gnds inh_vdd inh_vdds) LVT_NOR2x1_PB4_AFBB
    U613 (n588 n589 n587 inh_gnd inh_gnds inh_vdd inh_vdds) LVT_NOR2x1_PB4_AFBB
    U453 (n184 n74 n437 inh_gnd inh_gnds inh_vdd inh_vdds) LVT_NOR2x1_PB4_AFBB
    U452 (n436 n437 n435 inh_gnd inh_gnds inh_vdd inh_vdds) LVT_NOR2x1_PB4_AFBB
    U454 (n98 n106 n436 inh_gnd inh_gnds inh_vdd inh_vdds) LVT_NOR2x1_PB4_AFBB
    U457 (n151 n115 n439 inh_gnd inh_gnds inh_vdd inh_vdds) LVT_NOR2x1_PB4_AFBB
    U456 (n20 n377 n440 inh_gnd inh_gnds inh_vdd inh_vdds) LVT_NOR2x1_PB4_AFBB
    U455 (n439 n440 n434 inh_gnd inh_gnds inh_vdd inh_vdds) LVT_NOR2x1_PB4_AFBB
    U580 (n560 n561 n345 inh_gnd inh_gnds inh_vdd inh_vdds) LVT_NOR2x1_PB4_AFBB
    U602 (n578 n579 n343 inh_gnd inh_gnds inh_vdd inh_vdds) LVT_NOR2x1_PB4_AFBB
    U477 (n102 n33 sll_res\<1\> inh_gnd inh_gnds inh_vdd inh_vdds) LVT_NOR2x1_PB4_AFBB
    U550 (n532 n533 n312 inh_gnd inh_gnds inh_vdd inh_vdds) LVT_NOR2x1_PB4_AFBB
    U483 (n464 n465 n308 inh_gnd inh_gnds inh_vdd inh_vdds) LVT_NOR2x1_PB4_AFBB
    U672 (n151 n31 n649 inh_gnd inh_gnds inh_vdd inh_vdds) LVT_NOR2x1_PB4_AFBB
    U673 (n144 n613 n648 inh_gnd inh_gnds inh_vdd inh_vdds) LVT_NOR2x1_PB4_AFBB
    U671 (n648 n649 n646 inh_gnd inh_gnds inh_vdd inh_vdds) LVT_NOR2x1_PB4_AFBB
    U661 (n144 n89 n640 inh_gnd inh_gnds inh_vdd inh_vdds) LVT_NOR2x1_PB4_AFBB
    U662 (n126 n83 n639 inh_gnd inh_gnds inh_vdd inh_vdds) LVT_NOR2x1_PB4_AFBB
    U660 (n639 n640 n638 inh_gnd inh_gnds inh_vdd inh_vdds) LVT_NOR2x1_PB4_AFBB
    U665 (n151 n76 n641 inh_gnd inh_gnds inh_vdd inh_vdds) LVT_NOR2x1_PB4_AFBB
    U664 (n20 n93 n642 inh_gnd inh_gnds inh_vdd inh_vdds) LVT_NOR2x1_PB4_AFBB
    U663 (n641 n642 n637 inh_gnd inh_gnds inh_vdd inh_vdds) LVT_NOR2x1_PB4_AFBB
    U695 (n165 n1 sll_res\<0\> inh_gnd inh_gnds inh_vdd inh_vdds) LVT_NOR2x1_PB4_AFBB
    U336 (n302 n303 n301 inh_gnd inh_gnds inh_vdd inh_vdds) LVT_NOR2x1_PB4_AFBB
    U274 (n221 n222 n220 inh_gnd inh_gnds inh_vdd inh_vdds) LVT_NOR2x1_PB4_AFBB
    U411 (n392 n393 n228 inh_gnd inh_gnds inh_vdd inh_vdds) LVT_NOR2x1_PB4_AFBB
    U272 (n218 n219 n215 inh_gnd inh_gnds inh_vdd inh_vdds) LVT_NOR2x1_PB4_AFBB
    U281 (n176 n44 n218 inh_gnd inh_gnds inh_vdd inh_vdds) LVT_NOR2x1_PB4_AFBB
    U273 (n220 n1 n219 inh_gnd inh_gnds inh_vdd inh_vdds) LVT_NOR2x1_PB4_AFBB
    U266 (n208 n209 n207 inh_gnd inh_gnds inh_vdd inh_vdds) LVT_NOR2x1_PB4_AFBB
    U410 (n44 n101 n386 inh_gnd inh_gnds inh_vdd inh_vdds) LVT_NOR2x1_PB4_AFBB
    U418 (n399 n398 n384 inh_gnd inh_gnds inh_vdd inh_vdds) LVT_NOR2x1_PB4_AFBB
    U422 (n179 n403 n398 inh_gnd inh_gnds inh_vdd inh_vdds) LVT_NOR2x1_PB4_AFBB
    U406 (n387 n386 n385 inh_gnd inh_gnds inh_vdd inh_vdds) LVT_NOR2x1_PB4_AFBB
    U421 (n174 n88 n402 inh_gnd inh_gnds inh_vdd inh_vdds) LVT_NOR2x1_PB4_AFBB
    U445 (n186 n161 n390 inh_gnd inh_gnds inh_vdd inh_vdds) LVT_NOR2x1_PB4_AFBB
    U344 (n309 n310 n294 inh_gnd inh_gnds inh_vdd inh_vdds) LVT_NOR2x1_PB4_AFBB
    U346 (n87 n3 n309 inh_gnd inh_gnds inh_vdd inh_vdds) LVT_NOR2x1_PB4_AFBB
    U332 (n297 n296 n295 inh_gnd inh_gnds inh_vdd inh_vdds) LVT_NOR2x1_PB4_AFBB
    U343 (n308 n174 n296 inh_gnd inh_gnds inh_vdd inh_vdds) LVT_NOR2x1_PB4_AFBB
    U345 (n311 n38 n310 inh_gnd inh_gnds inh_vdd inh_vdds) LVT_NOR2x1_PB4_AFBB
    U658 (n403 n155 n628 inh_gnd inh_gnds inh_vdd inh_vdds) LVT_NOR2x1_PB4_AFBB
    U650 (n161 n472 n629 inh_gnd inh_gnds inh_vdd inh_vdds) LVT_NOR2x1_PB4_AFBB
    U649 (n628 n629 n619 inh_gnd inh_gnds inh_vdd inh_vdds) LVT_NOR2x1_PB4_AFBB
    U370 (n161 n37 n342 inh_gnd inh_gnds inh_vdd inh_vdds) LVT_NOR2x1_PB4_AFBB
    U369 (n341 n342 n339 inh_gnd inh_gnds inh_vdd inh_vdds) LVT_NOR2x1_PB4_AFBB
    U371 (n156 n50 n341 inh_gnd inh_gnds inh_vdd inh_vdds) LVT_NOR2x1_PB4_AFBB
    U490 (n173 n16 n460 inh_gnd inh_gnds inh_vdd inh_vdds) LVT_NOR2x1_PB4_AFBB
    U479 (n461 n460 n459 inh_gnd inh_gnds inh_vdd inh_vdds) LVT_NOR2x1_PB4_AFBB
    U560 (n160 n16 n538 inh_gnd inh_gnds inh_vdd inh_vdds) LVT_NOR2x1_PB4_AFBB
    U559 (n472 n141 n539 inh_gnd inh_gnds inh_vdd inh_vdds) LVT_NOR2x1_PB4_AFBB
    U558 (n539 n538 n528 inh_gnd inh_gnds inh_vdd inh_vdds) LVT_NOR2x1_PB4_AFBB
    U549 (n346 n87 n531 inh_gnd inh_gnds inh_vdd inh_vdds) LVT_NOR2x1_PB4_AFBB
    U557 (n51 n139 n530 inh_gnd inh_gnds inh_vdd inh_vdds) LVT_NOR2x1_PB4_AFBB
    U548 (n530 n531 n529 inh_gnd inh_gnds inh_vdd inh_vdds) LVT_NOR2x1_PB4_AFBB
    U694 (n7 B\<0\> n225 inh_gnd inh_gnds inh_vdd inh_vdds) LVT_NOR2x1_PB4_AFBB
    U693 (n151 n594 n664 inh_gnd inh_gnds inh_vdd inh_vdds) LVT_NOR2x1_PB4_AFBB
    U692 (n20 n91 n665 inh_gnd inh_gnds inh_vdd inh_vdds) LVT_NOR2x1_PB4_AFBB
    U691 (n664 n665 n659 inh_gnd inh_gnds inh_vdd inh_vdds) LVT_NOR2x1_PB4_AFBB
    U690 (n163 n80 n661 inh_gnd inh_gnds inh_vdd inh_vdds) LVT_NOR2x1_PB4_AFBB
    U688 (n124 n602 n662 inh_gnd inh_gnds inh_vdd inh_vdds) LVT_NOR2x1_PB4_AFBB
    U687 (n661 n662 n660 inh_gnd inh_gnds inh_vdd inh_vdds) LVT_NOR2x1_PB4_AFBB
    U287 (n239 n240 n238 inh_gnd inh_gnds inh_vdd inh_vdds) LVT_NOR2x1_PB4_AFBB
    U289 (n15 n69 n239 inh_gnd inh_gnds inh_vdd inh_vdds) LVT_NOR2x1_PB4_AFBB
    U288 (n124 n242 n240 inh_gnd inh_gnds inh_vdd inh_vdds) LVT_NOR2x1_PB4_AFBB
    U290 (n244 n245 n237 inh_gnd inh_gnds inh_vdd inh_vdds) LVT_NOR2x1_PB4_AFBB
    U292 (n151 n71 n244 inh_gnd inh_gnds inh_vdd inh_vdds) LVT_NOR2x1_PB4_AFBB
    U294 (n4 n249 n232 inh_gnd inh_gnds inh_vdd inh_vdds) LVT_NOR2x1_PB4_AFBB
    U295 (n250 n251 n230 inh_gnd inh_gnds inh_vdd inh_vdds) LVT_NOR2x1_PB4_AFBB
    U297 (n179 n40 n250 inh_gnd inh_gnds inh_vdd inh_vdds) LVT_NOR2x1_PB4_AFBB
    U283 (n233 n232 n231 inh_gnd inh_gnds inh_vdd inh_vdds) LVT_NOR2x1_PB4_AFBB
    U296 (n252 n130 n251 inh_gnd inh_gnds inh_vdd inh_vdds) LVT_NOR2x1_PB4_AFBB
    U575 (n5 n159 n553 inh_gnd inh_gnds inh_vdd inh_vdds) LVT_NOR2x1_PB4_AFBB
    U574 (n489 n141 n554 inh_gnd inh_gnds inh_vdd inh_vdds) LVT_NOR2x1_PB4_AFBB
    U573 (n554 n553 n541 inh_gnd inh_gnds inh_vdd inh_vdds) LVT_NOR2x1_PB4_AFBB
    U572 (n138 n254 n543 inh_gnd inh_gnds inh_vdd inh_vdds) LVT_NOR2x1_PB4_AFBB
    U564 (n332 n156 n544 inh_gnd inh_gnds inh_vdd inh_vdds) LVT_NOR2x1_PB4_AFBB
    U563 (n543 n544 n542 inh_gnd inh_gnds inh_vdd inh_vdds) LVT_NOR2x1_PB4_AFBB
    U675 (n651 n650 n644 inh_gnd inh_gnds inh_vdd inh_vdds) LVT_NOR2x1_PB4_AFBB
    U685 (n5 n155 n650 inh_gnd inh_gnds inh_vdd inh_vdds) LVT_NOR2x1_PB4_AFBB
    U676 (n160 n489 n651 inh_gnd inh_gnds inh_vdd inh_vdds) LVT_NOR2x1_PB4_AFBB
    U578 (n558 n559 n557 inh_gnd inh_gnds inh_vdd inh_vdds) LVT_NOR2x1_PB4_AFBB
    U579 (n159 n50 n559 inh_gnd inh_gnds inh_vdd inh_vdds) LVT_NOR2x1_PB4_AFBB
    U587 (n33 n139 n558 inh_gnd inh_gnds inh_vdd inh_vdds) LVT_NOR2x1_PB4_AFBB
    U593 (n156 n357 n569 inh_gnd inh_gnds inh_vdd inh_vdds) LVT_NOR2x1_PB4_AFBB
    U592 (n568 n569 n556 inh_gnd inh_gnds inh_vdd inh_vdds) LVT_NOR2x1_PB4_AFBB
    U601 (n36 n143 n568 inh_gnd inh_gnds inh_vdd inh_vdds) LVT_NOR2x1_PB4_AFBB
    U360 (n329 n330 n313 inh_gnd inh_gnds inh_vdd inh_vdds) LVT_NOR2x1_PB4_AFBB
    U348 (n316 n315 n314 inh_gnd inh_gnds inh_vdd inh_vdds) LVT_NOR2x1_PB4_AFBB
    U361 (n331 n56 n330 inh_gnd inh_gnds inh_vdd inh_vdds) LVT_NOR2x1_PB4_AFBB
    U362 (n332 n2 n329 inh_gnd inh_gnds inh_vdd inh_vdds) LVT_NOR2x1_PB4_AFBB
    U359 (n40 n174 n315 inh_gnd inh_gnds inh_vdd inh_vdds) LVT_NOR2x1_PB4_AFBB
    U355 (n324 n325 n319 inh_gnd inh_gnds inh_vdd inh_vdds) LVT_NOR2x1_PB4_AFBB
    U357 (n151 n112 n324 inh_gnd inh_gnds inh_vdd inh_vdds) LVT_NOR2x1_PB4_AFBB
    U356 (n20 n266 n325 inh_gnd inh_gnds inh_vdd inh_vdds) LVT_NOR2x1_PB4_AFBB
    U354 (n126 n110 n321 inh_gnd inh_gnds inh_vdd inh_vdds) LVT_NOR2x1_PB4_AFBB
    U353 (n182 n45 n322 inh_gnd inh_gnds inh_vdd inh_vdds) LVT_NOR2x1_PB4_AFBB
    U352 (n321 n322 n320 inh_gnd inh_gnds inh_vdd inh_vdds) LVT_NOR2x1_PB4_AFBB
    U312 (n271 n272 n255 inh_gnd inh_gnds inh_vdd inh_vdds) LVT_NOR2x1_PB4_AFBB
    U313 (n273 n129 n272 inh_gnd inh_gnds inh_vdd inh_vdds) LVT_NOR2x1_PB4_AFBB
    U314 (n25 n22 n271 inh_gnd inh_gnds inh_vdd inh_vdds) LVT_NOR2x1_PB4_AFBB
    U311 (n176 n270 n257 inh_gnd inh_gnds inh_vdd inh_vdds) LVT_NOR2x1_PB4_AFBB
    U300 (n258 n257 n256 inh_gnd inh_gnds inh_vdd inh_vdds) LVT_NOR2x1_PB4_AFBB
    U537 (n159 B\<4\> n192 inh_gnd inh_gnds inh_vdd inh_vdds) LVT_NOR2x1_PB4_AFBB
    U534 (n138 B\<4\> n212 inh_gnd inh_gnds inh_vdd inh_vdds) LVT_NOR2x1_PB4_AFBB
    U684 (n151 n616 n656 inh_gnd inh_gnds inh_vdd inh_vdds) LVT_NOR2x1_PB4_AFBB
    U683 (n20 n84 n657 inh_gnd inh_gnds inh_vdd inh_vdds) LVT_NOR2x1_PB4_AFBB
    U682 (n656 n657 n652 inh_gnd inh_gnds inh_vdd inh_vdds) LVT_NOR2x1_PB4_AFBB
    U681 (n163 n612 n654 inh_gnd inh_gnds inh_vdd inh_vdds) LVT_NOR2x1_PB4_AFBB
    U680 (n125 n591 n655 inh_gnd inh_gnds inh_vdd inh_vdds) LVT_NOR2x1_PB4_AFBB
    U679 (n654 n655 n653 inh_gnd inh_gnds inh_vdd inh_vdds) LVT_NOR2x1_PB4_AFBB
    U644 (n9 n136 n624 inh_gnd inh_gnds inh_vdd inh_vdds) LVT_NOR2x1_PB4_AFBB
    U645 (n98 n32 n623 inh_gnd inh_gnds inh_vdd inh_vdds) LVT_NOR2x1_PB4_AFBB
    U643 (n623 n624 n622 inh_gnd inh_gnds inh_vdd inh_vdds) LVT_NOR2x1_PB4_AFBB
    U648 (n151 n27 n626 inh_gnd inh_gnds inh_vdd inh_vdds) LVT_NOR2x1_PB4_AFBB
    U647 (n20 n60 n627 inh_gnd inh_gnds inh_vdd inh_vdds) LVT_NOR2x1_PB4_AFBB
    U646 (n626 n627 n621 inh_gnd inh_gnds inh_vdd inh_vdds) LVT_NOR2x1_PB4_AFBB
    U571 (n151 n120 n550 inh_gnd inh_gnds inh_vdd inh_vdds) LVT_NOR2x1_PB4_AFBB
    U570 (n20 n502 n551 inh_gnd inh_gnds inh_vdd inh_vdds) LVT_NOR2x1_PB4_AFBB
    U569 (n550 n551 n545 inh_gnd inh_gnds inh_vdd inh_vdds) LVT_NOR2x1_PB4_AFBB
    U568 (n163 n92 n547 inh_gnd inh_gnds inh_vdd inh_vdds) LVT_NOR2x1_PB4_AFBB
    U567 (n182 n78 n548 inh_gnd inh_gnds inh_vdd inh_vdds) LVT_NOR2x1_PB4_AFBB
    U566 (n547 n548 n546 inh_gnd inh_gnds inh_vdd inh_vdds) LVT_NOR2x1_PB4_AFBB
    U501 (n182 n64 n482 inh_gnd inh_gnds inh_vdd inh_vdds) LVT_NOR2x1_PB4_AFBB
    U502 (n126 n67 n481 inh_gnd inh_gnds inh_vdd inh_vdds) LVT_NOR2x1_PB4_AFBB
    U500 (n481 n482 n480 inh_gnd inh_gnds inh_vdd inh_vdds) LVT_NOR2x1_PB4_AFBB
    U505 (n151 n108 n484 inh_gnd inh_gnds inh_vdd inh_vdds) LVT_NOR2x1_PB4_AFBB
    U504 (n20 n438 n485 inh_gnd inh_gnds inh_vdd inh_vdds) LVT_NOR2x1_PB4_AFBB
    U503 (n484 n485 n479 inh_gnd inh_gnds inh_vdd inh_vdds) LVT_NOR2x1_PB4_AFBB
    U508 (n332 n168 n488 inh_gnd inh_gnds inh_vdd inh_vdds) LVT_NOR2x1_PB4_AFBB
    U509 (n17 n179 n487 inh_gnd inh_gnds inh_vdd inh_vdds) LVT_NOR2x1_PB4_AFBB
    U495 (n475 n476 n474 inh_gnd inh_gnds inh_vdd inh_vdds) LVT_NOR2x1_PB4_AFBB
    U506 (n5 n4 n475 inh_gnd inh_gnds inh_vdd inh_vdds) LVT_NOR2x1_PB4_AFBB
    U507 (n487 n488 n473 inh_gnd inh_gnds inh_vdd inh_vdds) LVT_NOR2x1_PB4_AFBB
    U436 (n418 n419 n404 inh_gnd inh_gnds inh_vdd inh_vdds) LVT_NOR2x1_PB4_AFBB
    U440 (n253 n5 n418 inh_gnd inh_gnds inh_vdd inh_vdds) LVT_NOR2x1_PB4_AFBB
    U424 (n406 n407 n405 inh_gnd inh_gnds inh_vdd inh_vdds) LVT_NOR2x1_PB4_AFBB
    U430 (n412 n413 n411 inh_gnd inh_gnds inh_vdd inh_vdds) LVT_NOR2x1_PB4_AFBB
    U432 (n126 n116 n412 inh_gnd inh_gnds inh_vdd inh_vdds) LVT_NOR2x1_PB4_AFBB
    U428 (n102 n249 n406 inh_gnd inh_gnds inh_vdd inh_vdds) LVT_NOR2x1_PB4_AFBB
    U435 (n151 n75 n415 inh_gnd inh_gnds inh_vdd inh_vdds) LVT_NOR2x1_PB4_AFBB
    U434 (n20 n351 n416 inh_gnd inh_gnds inh_vdd inh_vdds) LVT_NOR2x1_PB4_AFBB
    U433 (n415 n416 n410 inh_gnd inh_gnds inh_vdd inh_vdds) LVT_NOR2x1_PB4_AFBB
    U431 (n12 n113 n413 inh_gnd inh_gnds inh_vdd inh_vdds) LVT_NOR2x1_PB4_AFBB
    U653 (n9 n85 n633 inh_gnd inh_gnds inh_vdd inh_vdds) LVT_NOR2x1_PB4_AFBB
    U654 (n126 n62 n632 inh_gnd inh_gnds inh_vdd inh_vdds) LVT_NOR2x1_PB4_AFBB
    U652 (n632 n633 n631 inh_gnd inh_gnds inh_vdd inh_vdds) LVT_NOR2x1_PB4_AFBB
    U657 (n151 n103 n634 inh_gnd inh_gnds inh_vdd inh_vdds) LVT_NOR2x1_PB4_AFBB
    U656 (n20 n590 n635 inh_gnd inh_gnds inh_vdd inh_vdds) LVT_NOR2x1_PB4_AFBB
    U655 (n634 n635 n630 inh_gnd inh_gnds inh_vdd inh_vdds) LVT_NOR2x1_PB4_AFBB
    U597 (n126 n575 n573 inh_gnd inh_gnds inh_vdd inh_vdds) LVT_NOR2x1_PB4_AFBB
    U596 (n125 n119 n574 inh_gnd inh_gnds inh_vdd inh_vdds) LVT_NOR2x1_PB4_AFBB
    U595 (n573 n574 n572 inh_gnd inh_gnds inh_vdd inh_vdds) LVT_NOR2x1_PB4_AFBB
    U600 (n151 n549 n576 inh_gnd inh_gnds inh_vdd inh_vdds) LVT_NOR2x1_PB4_AFBB
    U599 (n20 n524 n577 inh_gnd inh_gnds inh_vdd inh_vdds) LVT_NOR2x1_PB4_AFBB
    U598 (n576 n577 n571 inh_gnd inh_gnds inh_vdd inh_vdds) LVT_NOR2x1_PB4_AFBB
    U518 (n125 n107 n501 inh_gnd inh_gnds inh_vdd inh_vdds) LVT_NOR2x1_PB4_AFBB
    U517 (n501 n500 n499 inh_gnd inh_gnds inh_vdd inh_vdds) LVT_NOR2x1_PB4_AFBB
    U519 (n15 n118 n500 inh_gnd inh_gnds inh_vdd inh_vdds) LVT_NOR2x1_PB4_AFBB
    U542 (n163 n79 n522 inh_gnd inh_gnds inh_vdd inh_vdds) LVT_NOR2x1_PB4_AFBB
    U540 (n523 n522 n521 inh_gnd inh_gnds inh_vdd inh_vdds) LVT_NOR2x1_PB4_AFBB
    U541 (n182 n483 n523 inh_gnd inh_gnds inh_vdd inh_vdds) LVT_NOR2x1_PB4_AFBB
    U383 (n25 n176 n355 inh_gnd inh_gnds inh_vdd inh_vdds) LVT_NOR2x1_PB4_AFBB
    U382 (n178 n10 n356 inh_gnd inh_gnds inh_vdd inh_vdds) LVT_NOR2x1_PB4_AFBB
    U364 (n336 n335 n334 inh_gnd inh_gnds inh_vdd inh_vdds) LVT_NOR2x1_PB4_AFBB
    U380 (n168 n270 n335 inh_gnd inh_gnds inh_vdd inh_vdds) LVT_NOR2x1_PB4_AFBB
    U381 (n355 n356 n333 inh_gnd inh_gnds inh_vdd inh_vdds) LVT_NOR2x1_PB4_AFBB
    U459 (n4 n10 n430 inh_gnd inh_gnds inh_vdd inh_vdds) LVT_NOR2x1_PB4_AFBB
    U442 (n426 n427 n425 inh_gnd inh_gnds inh_vdd inh_vdds) LVT_NOR2x1_PB4_AFBB
    U448 (n431 n430 n424 inh_gnd inh_gnds inh_vdd inh_vdds) LVT_NOR2x1_PB4_AFBB
    U524 (n357 n167 n506 inh_gnd inh_gnds inh_vdd inh_vdds) LVT_NOR2x1_PB4_AFBB
    U525 (n36 n180 n505 inh_gnd inh_gnds inh_vdd inh_vdds) LVT_NOR2x1_PB4_AFBB
    U523 (n505 n506 n490 inh_gnd inh_gnds inh_vdd inh_vdds) LVT_NOR2x1_PB4_AFBB
    U514 (n49 n173 n495 inh_gnd inh_gnds inh_vdd inh_vdds) LVT_NOR2x1_PB4_AFBB
    U512 (n496 n495 n494 inh_gnd inh_gnds inh_vdd inh_vdds) LVT_NOR2x1_PB4_AFBB
    U447 (n49 n178 n426 inh_gnd inh_gnds inh_vdd inh_vdds) LVT_NOR2x1_PB4_AFBB
    U522 (n151 n66 n503 inh_gnd inh_gnds inh_vdd inh_vdds) LVT_NOR2x1_PB4_AFBB
    U521 (n20 n453 n504 inh_gnd inh_gnds inh_vdd inh_vdds) LVT_NOR2x1_PB4_AFBB
    U520 (n503 n504 n498 inh_gnd inh_gnds inh_vdd inh_vdds) LVT_NOR2x1_PB4_AFBB
    U513 (n33 n13 n496 inh_gnd inh_gnds inh_vdd inh_vdds) LVT_NOR2x1_PB4_AFBB
    U379 (n151 n109 n352 inh_gnd inh_gnds inh_vdd inh_vdds) LVT_NOR2x1_PB4_AFBB
    U378 (n20 n285 n353 inh_gnd inh_gnds inh_vdd inh_vdds) LVT_NOR2x1_PB4_AFBB
    U377 (n352 n353 n347 inh_gnd inh_gnds inh_vdd inh_vdds) LVT_NOR2x1_PB4_AFBB
    U376 (n98 n73 n349 inh_gnd inh_gnds inh_vdd inh_vdds) LVT_NOR2x1_PB4_AFBB
    U375 (n183 n111 n350 inh_gnd inh_gnds inh_vdd inh_vdds) LVT_NOR2x1_PB4_AFBB
    U374 (n349 n350 n348 inh_gnd inh_gnds inh_vdd inh_vdds) LVT_NOR2x1_PB4_AFBB
    U304 (n264 n265 n263 inh_gnd inh_gnds inh_vdd inh_vdds) LVT_NOR2x1_PB4_AFBB
    U306 (n98 n30 n264 inh_gnd inh_gnds inh_vdd inh_vdds) LVT_NOR2x1_PB4_AFBB
    U305 (n183 n70 n265 inh_gnd inh_gnds inh_vdd inh_vdds) LVT_NOR2x1_PB4_AFBB
    U307 (n267 n268 n262 inh_gnd inh_gnds inh_vdd inh_vdds) LVT_NOR2x1_PB4_AFBB
    U308 (n20 n39 n268 inh_gnd inh_gnds inh_vdd inh_vdds) LVT_NOR2x1_PB4_AFBB
    U309 (n151 n68 n267 inh_gnd inh_gnds inh_vdd inh_vdds) LVT_NOR2x1_PB4_AFBB
    U532 (n142 B\<4\> n422 inh_gnd inh_gnds inh_vdd inh_vdds) LVT_NOR2x1_PB4_AFBB
    U491 (n470 n471 n458 inh_gnd inh_gnds inh_vdd inh_vdds) LVT_NOR2x1_PB4_AFBB
    U492 (n168 n88 n471 inh_gnd inh_gnds inh_vdd inh_vdds) LVT_NOR2x1_PB4_AFBB
    U493 (n23 n180 n470 inh_gnd inh_gnds inh_vdd inh_vdds) LVT_NOR2x1_PB4_AFBB
    U298 (n101 n254 sll_res\<2\> inh_gnd inh_gnds inh_vdd inh_vdds) LVT_NOR2x1_PB4_AFBB
    U265 (n102 n206 sll_res\<3\> inh_gnd inh_gnds inh_vdd inh_vdds) LVT_NOR2x1_PB4_AFBB
    U12 (B\<0\> B\<1\> n8 inh_gnd inh_gnds inh_vdd inh_vdds) LVT_NOR2x1_PB4_AFBB
    Thru31 (sll_res\<0\> C\<0\>) iprobe
    Thru30 (sll_res\<1\> C\<1\>) iprobe
    Thru29 (sll_res\<2\> C\<2\>) iprobe
    Thru28 (sll_res\<3\> C\<3\>) iprobe
    Thru27 (sll_res\<4\> C\<4\>) iprobe
    Thru26 (sll_res\<5\> C\<5\>) iprobe
    Thru25 (sll_res\<6\> C\<6\>) iprobe
    Thru24 (sll_res\<7\> C\<7\>) iprobe
    Thru23 (sll_res\<8\> C\<8\>) iprobe
    Thru22 (sll_res\<9\> C\<9\>) iprobe
    Thru21 (sll_res\<10\> C\<10\>) iprobe
    Thru20 (sll_res\<11\> C\<11\>) iprobe
    Thru19 (sll_res\<12\> C\<12\>) iprobe
    Thru18 (sll_res\<13\> C\<13\>) iprobe
    Thru17 (sll_res\<14\> C\<14\>) iprobe
    Thru16 (sll_res\<15\> C\<15\>) iprobe
    Thru15 (sll_res\<16\> C\<16\>) iprobe
    Thru14 (sll_res\<17\> C\<17\>) iprobe
    Thru13 (sll_res\<18\> C\<18\>) iprobe
    Thru12 (sll_res\<19\> C\<19\>) iprobe
    Thru11 (sll_res\<20\> C\<20\>) iprobe
    Thru10 (sll_res\<21\> C\<21\>) iprobe
    Thru9 (sll_res\<22\> C\<22\>) iprobe
    Thru8 (sll_res\<23\> C\<23\>) iprobe
    Thru7 (sll_res\<24\> C\<24\>) iprobe
    Thru6 (sll_res\<25\> C\<25\>) iprobe
    Thru5 (sll_res\<26\> C\<26\>) iprobe
    Thru4 (sll_res\<27\> C\<27\>) iprobe
    Thru3 (sll_res\<28\> C\<28\>) iprobe
    Thru2 (sll_res\<29\> C\<29\>) iprobe
    Thru1 (sll_res\<30\> C\<30\>) iprobe
    Thru0 (sll_res\<31\> C\<31\>) iprobe
ends alu_sll

// power_gating_fine/alu_sra/schematic
subckt alu_sra pwr_en A\<31\> A\<30\> A\<29\> A\<28\> A\<27\> A\<26\> A\<25\> A\<24\> A\<23\> A\<22\> A\<21\> A\<20\> A\<19\> A\<18\> A\<17\> A\<16\> A\<15\> A\<14\> A\<13\> A\<12\> A\<11\> A\<10\> A\<9\> A\<8\> A\<7\> A\<6\> A\<5\> A\<4\> A\<3\> A\<2\> A\<1\> A\<0\> B\<4\> B\<3\> B\<2\> B\<1\> B\<0\> C\<31\> C\<30\> C\<29\> C\<28\> C\<27\> C\<26\> C\<25\> C\<24\> C\<23\> C\<22\> C\<21\> C\<20\> C\<19\> C\<18\> C\<17\> C\<16\> C\<15\> C\<14\> C\<13\> C\<12\> C\<11\> C\<10\> C\<9\> C\<8\> C\<7\> C\<6\> C\<5\> C\<4\> C\<3\> C\<2\> C\<1\> C\<0\> inh_gnd inh_gnds vdd_in inh_vdds
    UG160 (pwr_en pwr_en_bar inh_gnd inh_gnds vdd_in inh_vdds) LVT_invx2_PB4_AFBB
    alu_sra_pwr_pmos (inh_vdd pwr_en_bar vdd_in inh_vdds) lvtpfet w=8000n l=30.00n nf=(2)*(1) ngcon=1 nsig_delvto_uo1=0 nsig_delvto_uo2=0 soa=1 swshe=0 swacc=0 swrg=0 swrsub=0 mismatch=1 m=1
    U53 (n462 n39 inh_gnd inh_gnds inh_vdd inh_vdds) LVT_invx2_PB4_AFBB
    U142 (n382 n112 inh_gnd inh_gnds inh_vdd inh_vdds) LVT_invx2_PB4_AFBB
    U91 (A\<26\> n583 inh_gnd inh_gnds inh_vdd inh_vdds) LVT_invx2_PB4_AFBB
    U212 (n313 n165 inh_gnd inh_gnds inh_vdd inh_vdds) LVT_invx2_PB4_AFBB
    U193 (n165 n152 inh_gnd inh_gnds inh_vdd inh_vdds) LVT_invx2_PB4_AFBB
    U247 (A\<27\> n563 inh_gnd inh_gnds inh_vdd inh_vdds) LVT_invx2_PB4_AFBB
    U79 (A\<24\> n586 inh_gnd inh_gnds inh_vdd inh_vdds) LVT_invx2_PB4_AFBB
    U129 (A\<25\> n104 inh_gnd inh_gnds inh_vdd inh_vdds) LVT_invx2_PB4_AFBB
    U275 (n269 n225 inh_gnd inh_gnds inh_vdd inh_vdds) LVT_invx2_PB4_AFBB
    U213 (n225 n166 inh_gnd inh_gnds inh_vdd inh_vdds) LVT_invx2_PB4_AFBB
    U21 (n657 sra_res\<0\> inh_gnd inh_gnds inh_vdd inh_vdds) LVT_invx2_PB4_AFBB
    U14 (n296 n7 inh_gnd inh_gnds inh_vdd inh_vdds) LVT_invx2_PB4_AFBB
    U145 (n228 n115 inh_gnd inh_gnds inh_vdd inh_vdds) LVT_invx2_PB4_AFBB
    U148 (n224 n118 inh_gnd inh_gnds inh_vdd inh_vdds) LVT_invx2_PB4_AFBB
    U205 (n282 n223 inh_gnd inh_gnds inh_vdd inh_vdds) LVT_invx2_PB4_AFBB
    U31 (n223 n19 inh_gnd inh_gnds inh_vdd inh_vdds) LVT_invx2_PB4_AFBB
    U23 (n420 n419 inh_gnd inh_gnds inh_vdd inh_vdds) LVT_invx2_PB4_AFBB
    U13 (n283 n6 inh_gnd inh_gnds inh_vdd inh_vdds) LVT_invx2_PB4_AFBB
    U238 (n447 n445 inh_gnd inh_gnds inh_vdd inh_vdds) LVT_invx2_PB4_AFBB
    U106 (n372 n371 inh_gnd inh_gnds inh_vdd inh_vdds) LVT_invx2_PB4_AFBB
    U4 (n111 n3 inh_gnd inh_gnds inh_vdd inh_vdds) LVT_invx2_PB4_AFBB
    U1 (A\<2\> n351 inh_gnd inh_gnds inh_vdd inh_vdds) LVT_invx2_PB4_AFBB
    U237 (B\<0\> n721 inh_gnd inh_gnds inh_vdd inh_vdds) LVT_invx2_PB4_AFBB
    U141 (n21 n111 inh_gnd inh_gnds inh_vdd inh_vdds) LVT_invx2_PB4_AFBB
    U234 (n311 n185 inh_gnd inh_gnds inh_vdd inh_vdds) LVT_invx2_PB4_AFBB
    U56 (n190 n42 inh_gnd inh_gnds inh_vdd inh_vdds) LVT_invx2_PB4_AFBB
    U140 (n21 n110 inh_gnd inh_gnds inh_vdd inh_vdds) LVT_invx2_PB4_AFBB
    U33 (n5 n21 inh_gnd inh_gnds inh_vdd inh_vdds) LVT_invx2_PB4_AFBB
    U260 (n190 n191 inh_gnd inh_gnds inh_vdd inh_vdds) LVT_invx2_PB4_AFBB
    U76 (n161 n60 inh_gnd inh_gnds inh_vdd inh_vdds) LVT_invx2_PB4_AFBB
    U34 (n379 n22 inh_gnd inh_gnds inh_vdd inh_vdds) LVT_invx2_PB4_AFBB
    U250 (A\<29\> n508 inh_gnd inh_gnds inh_vdd inh_vdds) LVT_invx2_PB4_AFBB
    U81 (A\<30\> n64 inh_gnd inh_gnds inh_vdd inh_vdds) LVT_invx2_PB4_AFBB
    U278 (B\<4\> n330 inh_gnd inh_gnds inh_vdd inh_vdds) LVT_invx2_PB4_AFBB
    U20 (n358 n11 inh_gnd inh_gnds inh_vdd inh_vdds) LVT_invx2_PB4_AFBB
    U276 (B\<4\> n204 inh_gnd inh_gnds inh_vdd inh_vdds) LVT_invx2_PB4_AFBB
    U233 (n496 n230 inh_gnd inh_gnds inh_vdd inh_vdds) LVT_invx2_PB4_AFBB
    U135 (B\<4\> n109 inh_gnd inh_gnds inh_vdd inh_vdds) LVT_invx2_PB4_AFBB
    U15 (n642 n8 inh_gnd inh_gnds inh_vdd inh_vdds) LVT_invx2_PB4_AFBB
    U264 (n103 n195 inh_gnd inh_gnds inh_vdd inh_vdds) LVT_invx2_PB4_AFBB
    U17 (n284 n283 inh_gnd inh_gnds inh_vdd inh_vdds) LVT_invx2_PB4_AFBB
    U117 (A\<6\> n94 inh_gnd inh_gnds inh_vdd inh_vdds) LVT_invx2_PB4_AFBB
    U71 (A\<5\> n55 inh_gnd inh_gnds inh_vdd inh_vdds) LVT_invx2_PB4_AFBB
    U169 (A\<8\> n136 inh_gnd inh_gnds inh_vdd inh_vdds) LVT_invx2_PB4_AFBB
    U151 (A\<7\> n121 inh_gnd inh_gnds inh_vdd inh_vdds) LVT_invx2_PB4_AFBB
    U11 (n517 n516 inh_gnd inh_gnds inh_vdd inh_vdds) LVT_invx2_PB4_AFBB
    U103 (n81 n82 inh_gnd inh_gnds inh_vdd inh_vdds) LVT_invx2_PB4_AFBB
    U102 (n229 n81 inh_gnd inh_gnds inh_vdd inh_vdds) LVT_invx2_PB4_AFBB
    U146 (n115 n116 inh_gnd inh_gnds inh_vdd inh_vdds) LVT_invx2_PB4_AFBB
    U147 (n115 n117 inh_gnd inh_gnds inh_vdd inh_vdds) LVT_invx2_PB4_AFBB
    U182 (n225 n146 inh_gnd inh_gnds inh_vdd inh_vdds) LVT_invx2_PB4_AFBB
    U57 (B\<0\> n43 inh_gnd inh_gnds inh_vdd inh_vdds) LVT_invx2_PB4_AFBB
    U259 (n432 n190 inh_gnd inh_gnds inh_vdd inh_vdds) LVT_invx2_PB4_AFBB
    U28 (B\<4\> n16 inh_gnd inh_gnds inh_vdd inh_vdds) LVT_invx2_PB4_AFBB
    U61 (B\<4\> n47 inh_gnd inh_gnds inh_vdd inh_vdds) LVT_invx2_PB4_AFBB
    U132 (B\<4\> n106 inh_gnd inh_gnds inh_vdd inh_vdds) LVT_invx2_PB4_AFBB
    U30 (B\<4\> n18 inh_gnd inh_gnds inh_vdd inh_vdds) LVT_invx2_PB4_AFBB
    U7 (n362 sra_res\<29\> inh_gnd inh_gnds inh_vdd inh_vdds) LVT_invx2_PB4_AFBB
    U143 (n112 n113 inh_gnd inh_gnds inh_vdd inh_vdds) LVT_invx2_PB4_AFBB
    U144 (n112 n114 inh_gnd inh_gnds inh_vdd inh_vdds) LVT_invx2_PB4_AFBB
    U149 (n118 n119 inh_gnd inh_gnds inh_vdd inh_vdds) LVT_invx2_PB4_AFBB
    U150 (n118 n120 inh_gnd inh_gnds inh_vdd inh_vdds) LVT_invx2_PB4_AFBB
    U221 (n173 n174 inh_gnd inh_gnds inh_vdd inh_vdds) LVT_invx2_PB4_AFBB
    U189 (n23 n364 inh_gnd inh_gnds inh_vdd inh_vdds) LVT_invx2_PB4_AFBB
    U35 (n22 n23 inh_gnd inh_gnds inh_vdd inh_vdds) LVT_invx2_PB4_AFBB
    U277 (B\<4\> n205 inh_gnd inh_gnds inh_vdd inh_vdds) LVT_invx2_PB4_AFBB
    U16 (n329 n9 inh_gnd inh_gnds inh_vdd inh_vdds) LVT_invx2_PB4_AFBB
    U27 (B\<4\> n15 inh_gnd inh_gnds inh_vdd inh_vdds) LVT_invx2_PB4_AFBB
    U227 (n176 n180 inh_gnd inh_gnds inh_vdd inh_vdds) LVT_invx2_PB4_AFBB
    U92 (n383 n71 inh_gnd inh_gnds inh_vdd inh_vdds) LVT_invx2_PB4_AFBB
    U224 (n71 n177 inh_gnd inh_gnds inh_vdd inh_vdds) LVT_invx2_PB4_AFBB
    U100 (n78 n79 inh_gnd inh_gnds inh_vdd inh_vdds) LVT_invx2_PB4_AFBB
    U36 (n331 n329 inh_gnd inh_gnds inh_vdd inh_vdds) LVT_invx2_PB4_AFBB
    U262 (n103 n193 inh_gnd inh_gnds inh_vdd inh_vdds) LVT_invx2_PB4_AFBB
    U128 (n194 n103 inh_gnd inh_gnds inh_vdd inh_vdds) LVT_invx2_PB4_AFBB
    U59 (B\<4\> n45 inh_gnd inh_gnds inh_vdd inh_vdds) LVT_invx2_PB4_AFBB
    U64 (A\<3\> n318 inh_gnd inh_gnds inh_vdd inh_vdds) LVT_invx2_PB4_AFBB
    U121 (A\<4\> n98 inh_gnd inh_gnds inh_vdd inh_vdds) LVT_invx2_PB4_AFBB
    U252 (A\<6\> n314 inh_gnd inh_gnds inh_vdd inh_vdds) LVT_invx2_PB4_AFBB
    U253 (A\<5\> n312 inh_gnd inh_gnds inh_vdd inh_vdds) LVT_invx2_PB4_AFBB
    U122 (A\<4\> n317 inh_gnd inh_gnds inh_vdd inh_vdds) LVT_invx2_PB4_AFBB
    U73 (A\<5\> n57 inh_gnd inh_gnds inh_vdd inh_vdds) LVT_invx2_PB4_AFBB
    U203 (n294 n293 inh_gnd inh_gnds inh_vdd inh_vdds) LVT_invx2_PB4_AFBB
    U37 (n297 n296 inh_gnd inh_gnds inh_vdd inh_vdds) LVT_invx2_PB4_AFBB
    U153 (A\<7\> n123 inh_gnd inh_gnds inh_vdd inh_vdds) LVT_invx2_PB4_AFBB
    U119 (A\<6\> n96 inh_gnd inh_gnds inh_vdd inh_vdds) LVT_invx2_PB4_AFBB
    U9 (n289 n288 inh_gnd inh_gnds inh_vdd inh_vdds) LVT_invx2_PB4_AFBB
    U232 (n181 n184 inh_gnd inh_gnds inh_vdd inh_vdds) LVT_invx2_PB4_AFBB
    U104 (n266 n262 inh_gnd inh_gnds inh_vdd inh_vdds) LVT_invx2_PB4_AFBB
    U54 (n39 n40 inh_gnd inh_gnds inh_vdd inh_vdds) LVT_invx2_PB4_AFBB
    U107 (B\<3\> n84 inh_gnd inh_gnds inh_vdd inh_vdds) LVT_invx2_PB4_AFBB
    U161 (B\<2\> n128 inh_gnd inh_gnds inh_vdd inh_vdds) LVT_invx2_PB4_AFBB
    U133 (B\<4\> n107 inh_gnd inh_gnds inh_vdd inh_vdds) LVT_invx2_PB4_AFBB
    U29 (B\<4\> n17 inh_gnd inh_gnds inh_vdd inh_vdds) LVT_invx2_PB4_AFBB
    U99 (n399 n78 inh_gnd inh_gnds inh_vdd inh_vdds) LVT_invx2_PB4_AFBB
    U266 (B\<2\> n453 inh_gnd inh_gnds inh_vdd inh_vdds) LVT_invx2_PB4_AFBB
    U223 (n383 n176 inh_gnd inh_gnds inh_vdd inh_vdds) LVT_invx2_PB4_AFBB
    U226 (n176 n179 inh_gnd inh_gnds inh_vdd inh_vdds) LVT_invx2_PB4_AFBB
    U263 (n192 n194 inh_gnd inh_gnds inh_vdd inh_vdds) LVT_invx2_PB4_AFBB
    U101 (n78 n80 inh_gnd inh_gnds inh_vdd inh_vdds) LVT_invx2_PB4_AFBB
    U269 (n160 n199 inh_gnd inh_gnds inh_vdd inh_vdds) LVT_invx2_PB4_AFBB
    U246 (A\<9\> n323 inh_gnd inh_gnds inh_vdd inh_vdds) LVT_invx2_PB4_AFBB
    U171 (A\<8\> n138 inh_gnd inh_gnds inh_vdd inh_vdds) LVT_invx2_PB4_AFBB
    U67 (n238 n709 inh_gnd inh_gnds inh_vdd inh_vdds) LVT_invx2_PB4_AFBB
    U66 (n709 n51 inh_gnd inh_gnds inh_vdd inh_vdds) LVT_invx2_PB4_AFBB
    U174 (A\<10\> n324 inh_gnd inh_gnds inh_vdd inh_vdds) LVT_invx2_PB4_AFBB
    U245 (A\<11\> n608 inh_gnd inh_gnds inh_vdd inh_vdds) LVT_invx2_PB4_AFBB
    U285 (n163 n212 inh_gnd inh_gnds inh_vdd inh_vdds) LVT_invx2_PB4_AFBB
    U210 (n161 n163 inh_gnd inh_gnds inh_vdd inh_vdds) LVT_invx2_PB4_AFBB
    U60 (B\<4\> n46 inh_gnd inh_gnds inh_vdd inh_vdds) LVT_invx2_PB4_AFBB
    U202 (n549 n389 inh_gnd inh_gnds inh_vdd inh_vdds) LVT_invx2_PB4_AFBB
    U190 (n491 n149 inh_gnd inh_gnds inh_vdd inh_vdds) LVT_invx2_PB4_AFBB
    U191 (n149 n150 inh_gnd inh_gnds inh_vdd inh_vdds) LVT_invx2_PB4_AFBB
    U47 (n686 n33 inh_gnd inh_gnds inh_vdd inh_vdds) LVT_invx2_PB4_AFBB
    U256 (n543 n242 inh_gnd inh_gnds inh_vdd inh_vdds) LVT_invx2_PB4_AFBB
    U244 (A\<12\> n607 inh_gnd inh_gnds inh_vdd inh_vdds) LVT_invx2_PB4_AFBB
    U243 (A\<13\> n603 inh_gnd inh_gnds inh_vdd inh_vdds) LVT_invx2_PB4_AFBB
    U242 (A\<15\> n597 inh_gnd inh_gnds inh_vdd inh_vdds) LVT_invx2_PB4_AFBB
    U86 (A\<14\> n67 inh_gnd inh_gnds inh_vdd inh_vdds) LVT_invx2_PB4_AFBB
    U187 (n548 n243 inh_gnd inh_gnds inh_vdd inh_vdds) LVT_invx2_PB4_AFBB
    U2 (n166 n1 inh_gnd inh_gnds inh_vdd inh_vdds) LVT_invx2_PB4_AFBB
    U125 (A\<22\> n569 inh_gnd inh_gnds inh_vdd inh_vdds) LVT_invx2_PB4_AFBB
    U240 (A\<20\> n572 inh_gnd inh_gnds inh_vdd inh_vdds) LVT_invx2_PB4_AFBB
    U249 (A\<21\> n568 inh_gnd inh_gnds inh_vdd inh_vdds) LVT_invx2_PB4_AFBB
    U241 (A\<23\> n587 inh_gnd inh_gnds inh_vdd inh_vdds) LVT_invx2_PB4_AFBB
    U287 (n162 n214 inh_gnd inh_gnds inh_vdd inh_vdds) LVT_invx2_PB4_AFBB
    U209 (n213 n162 inh_gnd inh_gnds inh_vdd inh_vdds) LVT_invx2_PB4_AFBB
    U286 (n165 n213 inh_gnd inh_gnds inh_vdd inh_vdds) LVT_invx2_PB4_AFBB
    U208 (n165 n161 inh_gnd inh_gnds inh_vdd inh_vdds) LVT_invx2_PB4_AFBB
    U255 (n686 n239 inh_gnd inh_gnds inh_vdd inh_vdds) LVT_invx2_PB4_AFBB
    U65 (n102 n50 inh_gnd inh_gnds inh_vdd inh_vdds) LVT_invx2_PB4_AFBB
    U177 (A\<18\> n593 inh_gnd inh_gnds inh_vdd inh_vdds) LVT_invx2_PB4_AFBB
    U239 (A\<16\> n596 inh_gnd inh_gnds inh_vdd inh_vdds) LVT_invx2_PB4_AFBB
    U248 (A\<17\> n592 inh_gnd inh_gnds inh_vdd inh_vdds) LVT_invx2_PB4_AFBB
    U180 (A\<19\> n573 inh_gnd inh_gnds inh_vdd inh_vdds) LVT_invx2_PB4_AFBB
    U130 (A\<25\> n105 inh_gnd inh_gnds inh_vdd inh_vdds) LVT_invx2_PB4_AFBB
    U77 (A\<24\> n61 inh_gnd inh_gnds inh_vdd inh_vdds) LVT_invx2_PB4_AFBB
    U51 (n465 n37 inh_gnd inh_gnds inh_vdd inh_vdds) LVT_invx2_PB4_AFBB
    U123 (A\<22\> n99 inh_gnd inh_gnds inh_vdd inh_vdds) LVT_invx2_PB4_AFBB
    U115 (A\<23\> n92 inh_gnd inh_gnds inh_vdd inh_vdds) LVT_invx2_PB4_AFBB
    U111 (A\<9\> n88 inh_gnd inh_gnds inh_vdd inh_vdds) LVT_invx2_PB4_AFBB
    U160 (n265 n264 inh_gnd inh_gnds inh_vdd inh_vdds) LVT_invx2_PB4_AFBB
    U170 (A\<8\> n137 inh_gnd inh_gnds inh_vdd inh_vdds) LVT_invx2_PB4_AFBB
    U118 (A\<6\> n95 inh_gnd inh_gnds inh_vdd inh_vdds) LVT_invx2_PB4_AFBB
    U152 (A\<7\> n122 inh_gnd inh_gnds inh_vdd inh_vdds) LVT_invx2_PB4_AFBB
    U211 (n161 n164 inh_gnd inh_gnds inh_vdd inh_vdds) LVT_invx2_PB4_AFBB
    U284 (n164 n211 inh_gnd inh_gnds inh_vdd inh_vdds) LVT_invx2_PB4_AFBB
    U274 (n146 n203 inh_gnd inh_gnds inh_vdd inh_vdds) LVT_invx2_PB4_AFBB
    U127 (n230 n102 inh_gnd inh_gnds inh_vdd inh_vdds) LVT_invx2_PB4_AFBB
    U204 (n359 n358 inh_gnd inh_gnds inh_vdd inh_vdds) LVT_invx2_PB4_AFBB
    U58 (B\<4\> n44 inh_gnd inh_gnds inh_vdd inh_vdds) LVT_invx2_PB4_AFBB
    U162 (B\<2\> n129 inh_gnd inh_gnds inh_vdd inh_vdds) LVT_invx2_PB4_AFBB
    U261 (n403 n192 inh_gnd inh_gnds inh_vdd inh_vdds) LVT_invx2_PB4_AFBB
    U265 (n192 n196 inh_gnd inh_gnds inh_vdd inh_vdds) LVT_invx2_PB4_AFBB
    U270 (n197 n200 inh_gnd inh_gnds inh_vdd inh_vdds) LVT_invx2_PB4_AFBB
    U52 (n37 n38 inh_gnd inh_gnds inh_vdd inh_vdds) LVT_invx2_PB4_AFBB
    U159 (n125 n127 inh_gnd inh_gnds inh_vdd inh_vdds) LVT_invx2_PB4_AFBB
    U155 (n648 n404 inh_gnd inh_gnds inh_vdd inh_vdds) LVT_invx2_PB4_AFBB
    U207 (n14 n370 inh_gnd inh_gnds inh_vdd inh_vdds) LVT_invx2_PB4_AFBB
    U281 (n145 n208 inh_gnd inh_gnds inh_vdd inh_vdds) LVT_invx2_PB4_AFBB
    U10 (n148 n4 inh_gnd inh_gnds inh_vdd inh_vdds) LVT_invx2_PB4_AFBB
    U200 (n156 n158 inh_gnd inh_gnds inh_vdd inh_vdds) LVT_invx2_PB4_AFBB
    U225 (n71 n178 inh_gnd inh_gnds inh_vdd inh_vdds) LVT_invx2_PB4_AFBB
    U46 (n71 n32 inh_gnd inh_gnds inh_vdd inh_vdds) LVT_invx2_PB4_AFBB
    U199 (n170 n157 inh_gnd inh_gnds inh_vdd inh_vdds) LVT_invx2_PB4_AFBB
    U217 (n167 n170 inh_gnd inh_gnds inh_vdd inh_vdds) LVT_invx2_PB4_AFBB
    U24 (n264 n12 inh_gnd inh_gnds inh_vdd inh_vdds) LVT_invx2_PB4_AFBB
    U63 (A\<3\> n49 inh_gnd inh_gnds inh_vdd inh_vdds) LVT_invx2_PB4_AFBB
    U72 (A\<5\> n56 inh_gnd inh_gnds inh_vdd inh_vdds) LVT_invx2_PB4_AFBB
    U120 (A\<4\> n97 inh_gnd inh_gnds inh_vdd inh_vdds) LVT_invx2_PB4_AFBB
    U40 (A\<21\> n26 inh_gnd inh_gnds inh_vdd inh_vdds) LVT_invx2_PB4_AFBB
    U113 (A\<20\> n90 inh_gnd inh_gnds inh_vdd inh_vdds) LVT_invx2_PB4_AFBB
    U74 (n268 n58 inh_gnd inh_gnds inh_vdd inh_vdds) LVT_invx2_PB4_AFBB
    U175 (A\<18\> n141 inh_gnd inh_gnds inh_vdd inh_vdds) LVT_invx2_PB4_AFBB
    U178 (A\<19\> n143 inh_gnd inh_gnds inh_vdd inh_vdds) LVT_invx2_PB4_AFBB
    U75 (n58 n59 inh_gnd inh_gnds inh_vdd inh_vdds) LVT_invx2_PB4_AFBB
    U22 (n259 n258 inh_gnd inh_gnds inh_vdd inh_vdds) LVT_invx2_PB4_AFBB
    U216 (n101 n169 inh_gnd inh_gnds inh_vdd inh_vdds) LVT_invx2_PB4_AFBB
    U257 (n490 n188 inh_gnd inh_gnds inh_vdd inh_vdds) LVT_invx2_PB4_AFBB
    U105 (n371 n83 inh_gnd inh_gnds inh_vdd inh_vdds) LVT_invx2_PB4_AFBB
    U93 (n335 n72 inh_gnd inh_gnds inh_vdd inh_vdds) LVT_invx2_PB4_AFBB
    U258 (n188 n189 inh_gnd inh_gnds inh_vdd inh_vdds) LVT_invx2_PB4_AFBB
    U229 (n230 n181 inh_gnd inh_gnds inh_vdd inh_vdds) LVT_invx2_PB4_AFBB
    U184 (n230 n148 inh_gnd inh_gnds inh_vdd inh_vdds) LVT_invx2_PB4_AFBB
    U3 (n166 n2 inh_gnd inh_gnds inh_vdd inh_vdds) LVT_invx2_PB4_AFBB
    U230 (n181 n182 inh_gnd inh_gnds inh_vdd inh_vdds) LVT_invx2_PB4_AFBB
    U231 (n148 n183 inh_gnd inh_gnds inh_vdd inh_vdds) LVT_invx2_PB4_AFBB
    U273 (n166 n202 inh_gnd inh_gnds inh_vdd inh_vdds) LVT_invx2_PB4_AFBB
    U186 (n480 n252 inh_gnd inh_gnds inh_vdd inh_vdds) LVT_invx2_PB4_AFBB
    U188 (n40 n337 inh_gnd inh_gnds inh_vdd inh_vdds) LVT_invx2_PB4_AFBB
    U8 (n334 sra_res\<30\> inh_gnd inh_gnds inh_vdd inh_vdds) LVT_invx2_PB4_AFBB
    U19 (n374 n642 inh_gnd inh_gnds inh_vdd inh_vdds) LVT_invx2_PB4_AFBB
    U195 (n153 n154 inh_gnd inh_gnds inh_vdd inh_vdds) LVT_invx2_PB4_AFBB
    U32 (n648 n20 inh_gnd inh_gnds inh_vdd inh_vdds) LVT_invx2_PB4_AFBB
    U90 (A\<26\> n70 inh_gnd inh_gnds inh_vdd inh_vdds) LVT_invx2_PB4_AFBB
    U167 (A\<27\> n134 inh_gnd inh_gnds inh_vdd inh_vdds) LVT_invx2_PB4_AFBB
    U68 (A\<29\> n52 inh_gnd inh_gnds inh_vdd inh_vdds) LVT_invx2_PB4_AFBB
    U85 (A\<28\> n562 inh_gnd inh_gnds inh_vdd inh_vdds) LVT_invx2_PB4_AFBB
    U134 (B\<4\> n108 inh_gnd inh_gnds inh_vdd inh_vdds) LVT_invx2_PB4_AFBB
    U137 (n635 n272 inh_gnd inh_gnds inh_vdd inh_vdds) LVT_invx2_PB4_AFBB
    U44 (A\<12\> n30 inh_gnd inh_gnds inh_vdd inh_vdds) LVT_invx2_PB4_AFBB
    U172 (A\<10\> n139 inh_gnd inh_gnds inh_vdd inh_vdds) LVT_invx2_PB4_AFBB
    U165 (A\<11\> n132 inh_gnd inh_gnds inh_vdd inh_vdds) LVT_invx2_PB4_AFBB
    U42 (A\<13\> n28 inh_gnd inh_gnds inh_vdd inh_vdds) LVT_invx2_PB4_AFBB
    U88 (A\<14\> n604 inh_gnd inh_gnds inh_vdd inh_vdds) LVT_invx2_PB4_AFBB
    U254 (n497 n273 inh_gnd inh_gnds inh_vdd inh_vdds) LVT_invx2_PB4_AFBB
    U163 (A\<16\> n130 inh_gnd inh_gnds inh_vdd inh_vdds) LVT_invx2_PB4_AFBB
    U215 (n101 n168 inh_gnd inh_gnds inh_vdd inh_vdds) LVT_invx2_PB4_AFBB
    U126 (n172 n101 inh_gnd inh_gnds inh_vdd inh_vdds) LVT_invx2_PB4_AFBB
    U87 (A\<14\> n68 inh_gnd inh_gnds inh_vdd inh_vdds) LVT_invx2_PB4_AFBB
    U109 (A\<15\> n86 inh_gnd inh_gnds inh_vdd inh_vdds) LVT_invx2_PB4_AFBB
    U38 (A\<17\> n24 inh_gnd inh_gnds inh_vdd inh_vdds) LVT_invx2_PB4_AFBB
    U43 (A\<13\> n29 inh_gnd inh_gnds inh_vdd inh_vdds) LVT_invx2_PB4_AFBB
    U136 (n598 n255 inh_gnd inh_gnds inh_vdd inh_vdds) LVT_invx2_PB4_AFBB
    U218 (n167 n171 inh_gnd inh_gnds inh_vdd inh_vdds) LVT_invx2_PB4_AFBB
    U214 (n172 n167 inh_gnd inh_gnds inh_vdd inh_vdds) LVT_invx2_PB4_AFBB
    U166 (A\<11\> n133 inh_gnd inh_gnds inh_vdd inh_vdds) LVT_invx2_PB4_AFBB
    U45 (A\<12\> n31 inh_gnd inh_gnds inh_vdd inh_vdds) LVT_invx2_PB4_AFBB
    U196 (n153 n155 inh_gnd inh_gnds inh_vdd inh_vdds) LVT_invx2_PB4_AFBB
    U194 (n380 n153 inh_gnd inh_gnds inh_vdd inh_vdds) LVT_invx2_PB4_AFBB
    U228 (B\<3\> n655 inh_gnd inh_gnds inh_vdd inh_vdds) LVT_invx2_PB4_AFBB
    U62 (A\<31\> n48 inh_gnd inh_gnds inh_vdd inh_vdds) LVT_invx2_PB4_AFBB
    U272 (n198 n378 inh_gnd inh_gnds inh_vdd inh_vdds) LVT_invx2_PB4_AFBB
    U26 (n13 n14 inh_gnd inh_gnds inh_vdd inh_vdds) LVT_invx2_PB4_AFBB
    U124 (A\<22\> n100 inh_gnd inh_gnds inh_vdd inh_vdds) LVT_invx2_PB4_AFBB
    U179 (A\<19\> n144 inh_gnd inh_gnds inh_vdd inh_vdds) LVT_invx2_PB4_AFBB
    U114 (A\<20\> n91 inh_gnd inh_gnds inh_vdd inh_vdds) LVT_invx2_PB4_AFBB
    U41 (A\<21\> n27 inh_gnd inh_gnds inh_vdd inh_vdds) LVT_invx2_PB4_AFBB
    U222 (n173 n175 inh_gnd inh_gnds inh_vdd inh_vdds) LVT_invx2_PB4_AFBB
    U220 (n147 n173 inh_gnd inh_gnds inh_vdd inh_vdds) LVT_invx2_PB4_AFBB
    U197 (A\<31\> n656 inh_gnd inh_gnds inh_vdd inh_vdds) LVT_invx2_PB4_AFBB
    U82 (A\<30\> n507 inh_gnd inh_gnds inh_vdd inh_vdds) LVT_invx2_PB4_AFBB
    U267 (n405 n197 inh_gnd inh_gnds inh_vdd inh_vdds) LVT_invx2_PB4_AFBB
    U271 (n197 n201 inh_gnd inh_gnds inh_vdd inh_vdds) LVT_invx2_PB4_AFBB
    U206 (n201 n160 inh_gnd inh_gnds inh_vdd inh_vdds) LVT_invx2_PB4_AFBB
    U108 (B\<3\> n85 inh_gnd inh_gnds inh_vdd inh_vdds) LVT_invx2_PB4_AFBB
    U198 (n281 n156 inh_gnd inh_gnds inh_vdd inh_vdds) LVT_invx2_PB4_AFBB
    U201 (n156 n159 inh_gnd inh_gnds inh_vdd inh_vdds) LVT_invx2_PB4_AFBB
    U50 (n35 n36 inh_gnd inh_gnds inh_vdd inh_vdds) LVT_invx2_PB4_AFBB
    U139 (n36 n367 inh_gnd inh_gnds inh_vdd inh_vdds) LVT_invx2_PB4_AFBB
    U6 (n365 sra_res\<28\> inh_gnd inh_gnds inh_vdd inh_vdds) LVT_invx2_PB4_AFBB
    U49 (n387 n35 inh_gnd inh_gnds inh_vdd inh_vdds) LVT_invx2_PB4_AFBB
    U282 (n206 n209 inh_gnd inh_gnds inh_vdd inh_vdds) LVT_invx2_PB4_AFBB
    U279 (n210 n206 inh_gnd inh_gnds inh_vdd inh_vdds) LVT_invx2_PB4_AFBB
    U95 (n72 n74 inh_gnd inh_gnds inh_vdd inh_vdds) LVT_invx2_PB4_AFBB
    U94 (n72 n73 inh_gnd inh_gnds inh_vdd inh_vdds) LVT_invx2_PB4_AFBB
    U268 (n160 n198 inh_gnd inh_gnds inh_vdd inh_vdds) LVT_invx2_PB4_AFBB
    U219 (n159 n172 inh_gnd inh_gnds inh_vdd inh_vdds) LVT_invx2_PB4_AFBB
    U138 (n481 n395 inh_gnd inh_gnds inh_vdd inh_vdds) LVT_invx2_PB4_AFBB
    U251 (A\<8\> n327 inh_gnd inh_gnds inh_vdd inh_vdds) LVT_invx2_PB4_AFBB
    U154 (A\<7\> n328 inh_gnd inh_gnds inh_vdd inh_vdds) LVT_invx2_PB4_AFBB
    U173 (A\<10\> n140 inh_gnd inh_gnds inh_vdd inh_vdds) LVT_invx2_PB4_AFBB
    U80 (A\<30\> n63 inh_gnd inh_gnds inh_vdd inh_vdds) LVT_invx2_PB4_AFBB
    U25 (n393 n13 inh_gnd inh_gnds inh_vdd inh_vdds) LVT_invx2_PB4_AFBB
    U69 (A\<29\> n53 inh_gnd inh_gnds inh_vdd inh_vdds) LVT_invx2_PB4_AFBB
    U235 (n185 n186 inh_gnd inh_gnds inh_vdd inh_vdds) LVT_invx2_PB4_AFBB
    U168 (A\<27\> n135 inh_gnd inh_gnds inh_vdd inh_vdds) LVT_invx2_PB4_AFBB
    U84 (A\<28\> n66 inh_gnd inh_gnds inh_vdd inh_vdds) LVT_invx2_PB4_AFBB
    U5 (n368 sra_res\<27\> inh_gnd inh_gnds inh_vdd inh_vdds) LVT_invx2_PB4_AFBB
    U48 (n145 n34 inh_gnd inh_gnds inh_vdd inh_vdds) LVT_invx2_PB4_AFBB
    U156 (n185 n124 inh_gnd inh_gnds inh_vdd inh_vdds) LVT_invx2_PB4_AFBB
    U112 (A\<9\> n89 inh_gnd inh_gnds inh_vdd inh_vdds) LVT_invx2_PB4_AFBB
    U158 (n125 n126 inh_gnd inh_gnds inh_vdd inh_vdds) LVT_invx2_PB4_AFBB
    U157 (n222 n125 inh_gnd inh_gnds inh_vdd inh_vdds) LVT_invx2_PB4_AFBB
    U283 (n222 n210 inh_gnd inh_gnds inh_vdd inh_vdds) LVT_invx2_PB4_AFBB
    U181 (n210 n145 inh_gnd inh_gnds inh_vdd inh_vdds) LVT_invx2_PB4_AFBB
    U185 (n484 n256 inh_gnd inh_gnds inh_vdd inh_vdds) LVT_invx2_PB4_AFBB
    U39 (A\<17\> n25 inh_gnd inh_gnds inh_vdd inh_vdds) LVT_invx2_PB4_AFBB
    U110 (A\<15\> n87 inh_gnd inh_gnds inh_vdd inh_vdds) LVT_invx2_PB4_AFBB
    U164 (A\<16\> n131 inh_gnd inh_gnds inh_vdd inh_vdds) LVT_invx2_PB4_AFBB
    U176 (A\<18\> n142 inh_gnd inh_gnds inh_vdd inh_vdds) LVT_invx2_PB4_AFBB
    U192 (n164 n151 inh_gnd inh_gnds inh_vdd inh_vdds) LVT_invx2_PB4_AFBB
    U55 (n164 n41 inh_gnd inh_gnds inh_vdd inh_vdds) LVT_invx2_PB4_AFBB
    U89 (A\<26\> n69 inh_gnd inh_gnds inh_vdd inh_vdds) LVT_invx2_PB4_AFBB
    U116 (A\<23\> n93 inh_gnd inh_gnds inh_vdd inh_vdds) LVT_invx2_PB4_AFBB
    U78 (A\<24\> n62 inh_gnd inh_gnds inh_vdd inh_vdds) LVT_invx2_PB4_AFBB
    U131 (A\<25\> n582 inh_gnd inh_gnds inh_vdd inh_vdds) LVT_invx2_PB4_AFBB
    U83 (A\<28\> n65 inh_gnd inh_gnds inh_vdd inh_vdds) LVT_invx2_PB4_AFBB
    U70 (A\<29\> n54 inh_gnd inh_gnds inh_vdd inh_vdds) LVT_invx2_PB4_AFBB
    U280 (n145 n207 inh_gnd inh_gnds inh_vdd inh_vdds) LVT_invx2_PB4_AFBB
    U236 (n185 n187 inh_gnd inh_gnds inh_vdd inh_vdds) LVT_invx2_PB4_AFBB
    U538 (n520 n521 n382 inh_gnd inh_gnds inh_vdd inh_vdds) LVT_NOR2x1_PB4_AFBB
    U680 (n311 n583 n669 inh_gnd inh_gnds inh_vdd inh_vdds) LVT_NOR2x1_PB4_AFBB
    U679 (n668 n669 n667 inh_gnd inh_gnds inh_vdd inh_vdds) LVT_NOR2x1_PB4_AFBB
    U681 (n152 n563 n668 inh_gnd inh_gnds inh_vdd inh_vdds) LVT_NOR2x1_PB4_AFBB
    U684 (n21 n586 n670 inh_gnd inh_gnds inh_vdd inh_vdds) LVT_NOR2x1_PB4_AFBB
    U683 (n190 n104 n671 inh_gnd inh_gnds inh_vdd inh_vdds) LVT_NOR2x1_PB4_AFBB
    U682 (n671 n670 n666 inh_gnd inh_gnds inh_vdd inh_vdds) LVT_NOR2x1_PB4_AFBB
    U745 (n717 n718 n716 inh_gnd inh_gnds inh_vdd inh_vdds) LVT_NOR2x1_PB4_AFBB
    U742 (n716 n125 n707 inh_gnd inh_gnds inh_vdd inh_vdds) LVT_NOR2x1_PB4_AFBB
    U731 (n707 n708 n699 inh_gnd inh_gnds inh_vdd inh_vdds) LVT_NOR2x1_PB4_AFBB
    U732 (n184 n709 n708 inh_gnd inh_gnds inh_vdd inh_vdds) LVT_NOR2x1_PB4_AFBB
    U729 (n461 B\<4\> n269 inh_gnd inh_gnds inh_vdd inh_vdds) LVT_NOR2x1_PB4_AFBB
    U672 (n658 n659 n657 inh_gnd inh_gnds inh_vdd inh_vdds) LVT_NOR2x1_PB4_AFBB
    U546 (n526 n527 n229 inh_gnd inh_gnds inh_vdd inh_vdds) LVT_NOR2x1_PB4_AFBB
    U554 (n532 n533 n228 inh_gnd inh_gnds inh_vdd inh_vdds) LVT_NOR2x1_PB4_AFBB
    U528 (n509 n510 n224 inh_gnd inh_gnds inh_vdd inh_vdds) LVT_NOR2x1_PB4_AFBB
    U453 (n433 n434 n282 inh_gnd inh_gnds inh_vdd inh_vdds) LVT_NOR2x1_PB4_AFBB
    U445 (n426 n427 n425 inh_gnd inh_gnds inh_vdd inh_vdds) LVT_NOR2x1_PB4_AFBB
    U444 (n425 n207 n424 inh_gnd inh_gnds inh_vdd inh_vdds) LVT_NOR2x1_PB4_AFBB
    U452 (n184 n19 n423 inh_gnd inh_gnds inh_vdd inh_vdds) LVT_NOR2x1_PB4_AFBB
    U443 (n423 n424 n422 inh_gnd inh_gnds inh_vdd inh_vdds) LVT_NOR2x1_PB4_AFBB
    U469 (n203 n117 n446 inh_gnd inh_gnds inh_vdd inh_vdds) LVT_NOR2x1_PB4_AFBB
    U468 (n446 n445 n418 inh_gnd inh_gnds inh_vdd inh_vdds) LVT_NOR2x1_PB4_AFBB
    U377 (n351 n3 n349 inh_gnd inh_gnds inh_vdd inh_vdds) LVT_NOR2x1_PB4_AFBB
    U12 (B\<0\> B\<1\> n5 inh_gnd inh_gnds inh_vdd inh_vdds) LVT_NOR2x1_PB4_AFBB
    U526 (n21 n508 n505 inh_gnd inh_gnds inh_vdd inh_vdds) LVT_NOR2x1_PB4_AFBB
    U525 (n190 n64 n506 inh_gnd inh_gnds inh_vdd inh_vdds) LVT_NOR2x1_PB4_AFBB
    U524 (n505 n506 n503 inh_gnd inh_gnds inh_vdd inh_vdds) LVT_NOR2x1_PB4_AFBB
    U497 (n193 n113 n471 inh_gnd inh_gnds inh_vdd inh_vdds) LVT_NOR2x1_PB4_AFBB
    U733 (n193 B\<4\> n496 inh_gnd inh_gnds inh_vdd inh_vdds) LVT_NOR2x1_PB4_AFBB
    U496 (n180 n82 n472 inh_gnd inh_gnds inh_vdd inh_vdds) LVT_NOR2x1_PB4_AFBB
    U429 (n180 n119 n409 inh_gnd inh_gnds inh_vdd inh_vdds) LVT_NOR2x1_PB4_AFBB
    U495 (n471 n472 n467 inh_gnd inh_gnds inh_vdd inh_vdds) LVT_NOR2x1_PB4_AFBB
    U494 (n76 n364 n469 inh_gnd inh_gnds inh_vdd inh_vdds) LVT_NOR2x1_PB4_AFBB
    U493 (n201 n120 n470 inh_gnd inh_gnds inh_vdd inh_vdds) LVT_NOR2x1_PB4_AFBB
    U432 (n201 n114 n410 inh_gnd inh_gnds inh_vdd inh_vdds) LVT_NOR2x1_PB4_AFBB
    U492 (n469 n470 n468 inh_gnd inh_gnds inh_vdd inh_vdds) LVT_NOR2x1_PB4_AFBB
    U431 (n364 n195 n411 inh_gnd inh_gnds inh_vdd inh_vdds) LVT_NOR2x1_PB4_AFBB
    U430 (n411 n410 n407 inh_gnd inh_gnds inh_vdd inh_vdds) LVT_NOR2x1_PB4_AFBB
    U428 (n409 n79 n408 inh_gnd inh_gnds inh_vdd inh_vdds) LVT_NOR2x1_PB4_AFBB
    U325 (n277 n276 n275 inh_gnd inh_gnds inh_vdd inh_vdds) LVT_NOR2x1_PB4_AFBB
    U332 (n82 n2 n285 inh_gnd inh_gnds inh_vdd inh_vdds) LVT_NOR2x1_PB4_AFBB
    U331 (n183 n116 n286 inh_gnd inh_gnds inh_vdd inh_vdds) LVT_NOR2x1_PB4_AFBB
    U330 (n285 n286 n274 inh_gnd inh_gnds inh_vdd inh_vdds) LVT_NOR2x1_PB4_AFBB
    U465 (n443 n444 n439 inh_gnd inh_gnds inh_vdd inh_vdds) LVT_NOR2x1_PB4_AFBB
    U466 (n190 n94 n444 inh_gnd inh_gnds inh_vdd inh_vdds) LVT_NOR2x1_PB4_AFBB
    U329 (n34 n283 n276 inh_gnd inh_gnds inh_vdd inh_vdds) LVT_NOR2x1_PB4_AFBB
    U467 (n21 n55 n443 inh_gnd inh_gnds inh_vdd inh_vdds) LVT_NOR2x1_PB4_AFBB
    U464 (n211 n136 n441 inh_gnd inh_gnds inh_vdd inh_vdds) LVT_NOR2x1_PB4_AFBB
    U463 (n124 n121 n442 inh_gnd inh_gnds inh_vdd inh_vdds) LVT_NOR2x1_PB4_AFBB
    U462 (n441 n442 n440 inh_gnd inh_gnds inh_vdd inh_vdds) LVT_NOR2x1_PB4_AFBB
    U537 (n114 n202 n519 inh_gnd inh_gnds inh_vdd inh_vdds) LVT_NOR2x1_PB4_AFBB
    U545 (n82 n168 n518 inh_gnd inh_gnds inh_vdd inh_vdds) LVT_NOR2x1_PB4_AFBB
    U536 (n519 n518 n517 inh_gnd inh_gnds inh_vdd inh_vdds) LVT_NOR2x1_PB4_AFBB
    U553 (n208 n116 n515 inh_gnd inh_gnds inh_vdd inh_vdds) LVT_NOR2x1_PB4_AFBB
    U535 (n515 n516 n498 inh_gnd inh_gnds inh_vdd inh_vdds) LVT_NOR2x1_PB4_AFBB
    U296 (n229 n4 n226 inh_gnd inh_gnds inh_vdd inh_vdds) LVT_NOR2x1_PB4_AFBB
    U527 (n4 n119 n500 inh_gnd inh_gnds inh_vdd inh_vdds) LVT_NOR2x1_PB4_AFBB
    U519 (n500 n501 n499 inh_gnd inh_gnds inh_vdd inh_vdds) LVT_NOR2x1_PB4_AFBB
    U295 (n117 n169 n227 inh_gnd inh_gnds inh_vdd inh_vdds) LVT_NOR2x1_PB4_AFBB
    U294 (n226 n227 n215 inh_gnd inh_gnds inh_vdd inh_vdds) LVT_NOR2x1_PB4_AFBB
    U293 (n225 n120 n217 inh_gnd inh_gnds inh_vdd inh_vdds) LVT_NOR2x1_PB4_AFBB
    U289 (n218 n217 n216 inh_gnd inh_gnds inh_vdd inh_vdds) LVT_NOR2x1_PB4_AFBB
    U749 (n43 B\<1\> n432 inh_gnd inh_gnds inh_vdd inh_vdds) LVT_NOR2x1_PB4_AFBB
    U403 (n381 n155 n376 inh_gnd inh_gnds inh_vdd inh_vdds) LVT_NOR2x1_PB4_AFBB
    U404 (n113 n32 n381 inh_gnd inh_gnds inh_vdd inh_vdds) LVT_NOR2x1_PB4_AFBB
    U391 (n22 n210 n363 inh_gnd inh_gnds inh_vdd inh_vdds) LVT_NOR2x1_PB4_AFBB
    U390 (n363 n73 n362 inh_gnd inh_gnds inh_vdd inh_vdds) LVT_NOR2x1_PB4_AFBB
    U702 (n180 n33 n678 inh_gnd inh_gnds inh_vdd inh_vdds) LVT_NOR2x1_PB4_AFBB
    U694 (n199 n243 n679 inh_gnd inh_gnds inh_vdd inh_vdds) LVT_NOR2x1_PB4_AFBB
    U439 (n243 n177 n417 inh_gnd inh_gnds inh_vdd inh_vdds) LVT_NOR2x1_PB4_AFBB
    U693 (n678 n679 n662 inh_gnd inh_gnds inh_vdd inh_vdds) LVT_NOR2x1_PB4_AFBB
    U685 (n77 n367 n664 inh_gnd inh_gnds inh_vdd inh_vdds) LVT_NOR2x1_PB4_AFBB
    U677 (n194 n389 n665 inh_gnd inh_gnds inh_vdd inh_vdds) LVT_NOR2x1_PB4_AFBB
    U440 (n389 n200 n416 inh_gnd inh_gnds inh_vdd inh_vdds) LVT_NOR2x1_PB4_AFBB
    U676 (n664 n665 n663 inh_gnd inh_gnds inh_vdd inh_vdds) LVT_NOR2x1_PB4_AFBB
    U475 (n252 n179 n452 inh_gnd inh_gnds inh_vdd inh_vdds) LVT_NOR2x1_PB4_AFBB
    U474 (n452 n79 n451 inh_gnd inh_gnds inh_vdd inh_vdds) LVT_NOR2x1_PB4_AFBB
    U479 (n199 n395 n454 inh_gnd inh_gnds inh_vdd inh_vdds) LVT_NOR2x1_PB4_AFBB
    U478 (n193 n370 n455 inh_gnd inh_gnds inh_vdd inh_vdds) LVT_NOR2x1_PB4_AFBB
    U477 (n455 n454 n450 inh_gnd inh_gnds inh_vdd inh_vdds) LVT_NOR2x1_PB4_AFBB
    U361 (n45 n329 n302 inh_gnd inh_gnds inh_vdd inh_vdds) LVT_NOR2x1_PB4_AFBB
    U343 (n303 n302 n301 inh_gnd inh_gnds inh_vdd inh_vdds) LVT_NOR2x1_PB4_AFBB
    U364 (n256 n1 n332 inh_gnd inh_gnds inh_vdd inh_vdds) LVT_NOR2x1_PB4_AFBB
    U363 (n255 n50 n333 inh_gnd inh_gnds inh_vdd inh_vdds) LVT_NOR2x1_PB4_AFBB
    U362 (n332 n333 n300 inh_gnd inh_gnds inh_vdd inh_vdds) LVT_NOR2x1_PB4_AFBB
    U352 (n21 n318 n315 inh_gnd inh_gnds inh_vdd inh_vdds) LVT_NOR2x1_PB4_AFBB
    U351 (n190 n98 n316 inh_gnd inh_gnds inh_vdd inh_vdds) LVT_NOR2x1_PB4_AFBB
    U350 (n315 n316 n307 inh_gnd inh_gnds inh_vdd inh_vdds) LVT_NOR2x1_PB4_AFBB
    U349 (n212 n314 n309 inh_gnd inh_gnds inh_vdd inh_vdds) LVT_NOR2x1_PB4_AFBB
    U348 (n187 n312 n310 inh_gnd inh_gnds inh_vdd inh_vdds) LVT_NOR2x1_PB4_AFBB
    U347 (n310 n309 n308 inh_gnd inh_gnds inh_vdd inh_vdds) LVT_NOR2x1_PB4_AFBB
    U438 (n416 n417 n413 inh_gnd inh_gnds inh_vdd inh_vdds) LVT_NOR2x1_PB4_AFBB
    U436 (n415 n80 n414 inh_gnd inh_gnds inh_vdd inh_vdds) LVT_NOR2x1_PB4_AFBB
    U437 (n194 n35 n415 inh_gnd inh_gnds inh_vdd inh_vdds) LVT_NOR2x1_PB4_AFBB
    U715 (n697 n698 n693 inh_gnd inh_gnds inh_vdd inh_vdds) LVT_NOR2x1_PB4_AFBB
    U717 (n21 n317 n697 inh_gnd inh_gnds inh_vdd inh_vdds) LVT_NOR2x1_PB4_AFBB
    U716 (n190 n57 n698 inh_gnd inh_gnds inh_vdd inh_vdds) LVT_NOR2x1_PB4_AFBB
    U335 (n292 n293 n291 inh_gnd inh_gnds inh_vdd inh_vdds) LVT_NOR2x1_PB4_AFBB
    U337 (n208 n296 n292 inh_gnd inh_gnds inh_vdd inh_vdds) LVT_NOR2x1_PB4_AFBB
    U714 (n151 n123 n695 inh_gnd inh_gnds inh_vdd inh_vdds) LVT_NOR2x1_PB4_AFBB
    U713 (n186 n96 n696 inh_gnd inh_gnds inh_vdd inh_vdds) LVT_NOR2x1_PB4_AFBB
    U712 (n695 n696 n694 inh_gnd inh_gnds inh_vdd inh_vdds) LVT_NOR2x1_PB4_AFBB
    U341 (n242 n184 n298 inh_gnd inh_gnds inh_vdd inh_vdds) LVT_NOR2x1_PB4_AFBB
    U340 (n203 n239 n299 inh_gnd inh_gnds inh_vdd inh_vdds) LVT_NOR2x1_PB4_AFBB
    U339 (n298 n299 n287 inh_gnd inh_gnds inh_vdd inh_vdds) LVT_NOR2x1_PB4_AFBB
    U420 (n400 n80 n398 inh_gnd inh_gnds inh_vdd inh_vdds) LVT_NOR2x1_PB4_AFBB
    U421 (n37 n178 n400 inh_gnd inh_gnds inh_vdd inh_vdds) LVT_NOR2x1_PB4_AFBB
    U424 (n199 n404 n401 inh_gnd inh_gnds inh_vdd inh_vdds) LVT_NOR2x1_PB4_AFBB
    U423 (n39 n196 n402 inh_gnd inh_gnds inh_vdd inh_vdds) LVT_NOR2x1_PB4_AFBB
    U422 (n402 n401 n397 inh_gnd inh_gnds inh_vdd inh_vdds) LVT_NOR2x1_PB4_AFBB
    U476 (n153 n453 n399 inh_gnd inh_gnds inh_vdd inh_vdds) LVT_NOR2x1_PB4_AFBB
    U743 (n179 B\<4\> n222 inh_gnd inh_gnds inh_vdd inh_vdds) LVT_NOR2x1_PB4_AFBB
    U739 (n714 n715 n710 inh_gnd inh_gnds inh_vdd inh_vdds) LVT_NOR2x1_PB4_AFBB
    U740 (n190 n323 n715 inh_gnd inh_gnds inh_vdd inh_vdds) LVT_NOR2x1_PB4_AFBB
    U741 (n21 n138 n714 inh_gnd inh_gnds inh_vdd inh_vdds) LVT_NOR2x1_PB4_AFBB
    U298 (n233 n234 n232 inh_gnd inh_gnds inh_vdd inh_vdds) LVT_NOR2x1_PB4_AFBB
    U736 (n713 n712 n711 inh_gnd inh_gnds inh_vdd inh_vdds) LVT_NOR2x1_PB4_AFBB
    U737 (n186 n324 n713 inh_gnd inh_gnds inh_vdd inh_vdds) LVT_NOR2x1_PB4_AFBB
    U738 (n212 n608 n712 inh_gnd inh_gnds inh_vdd inh_vdds) LVT_NOR2x1_PB4_AFBB
    U410 (n177 n389 n388 inh_gnd inh_gnds inh_vdd inh_vdds) LVT_NOR2x1_PB4_AFBB
    U409 (n154 n388 n385 inh_gnd inh_gnds inh_vdd inh_vdds) LVT_NOR2x1_PB4_AFBB
    U585 (n177 n46 n491 inh_gnd inh_gnds inh_vdd inh_vdds) LVT_NOR2x1_PB4_AFBB
    U570 (n170 n33 n544 inh_gnd inh_gnds inh_vdd inh_vdds) LVT_NOR2x1_PB4_AFBB
    U566 (n545 n544 n538 inh_gnd inh_gnds inh_vdd inh_vdds) LVT_NOR2x1_PB4_AFBB
    U565 (n242 n34 n540 inh_gnd inh_gnds inh_vdd inh_vdds) LVT_NOR2x1_PB4_AFBB
    U562 (n540 n541 n539 inh_gnd inh_gnds inh_vdd inh_vdds) LVT_NOR2x1_PB4_AFBB
    U303 (n240 n241 n231 inh_gnd inh_gnds inh_vdd inh_vdds) LVT_NOR2x1_PB4_AFBB
    U304 (n242 n171 n241 inh_gnd inh_gnds inh_vdd inh_vdds) LVT_NOR2x1_PB4_AFBB
    U728 (n21 n607 n705 inh_gnd inh_gnds inh_vdd inh_vdds) LVT_NOR2x1_PB4_AFBB
    U727 (n190 n603 n706 inh_gnd inh_gnds inh_vdd inh_vdds) LVT_NOR2x1_PB4_AFBB
    U726 (n705 n706 n701 inh_gnd inh_gnds inh_vdd inh_vdds) LVT_NOR2x1_PB4_AFBB
    U725 (n211 n597 n703 inh_gnd inh_gnds inh_vdd inh_vdds) LVT_NOR2x1_PB4_AFBB
    U724 (n124 n67 n704 inh_gnd inh_gnds inh_vdd inh_vdds) LVT_NOR2x1_PB4_AFBB
    U723 (n703 n704 n702 inh_gnd inh_gnds inh_vdd inh_vdds) LVT_NOR2x1_PB4_AFBB
    U305 (n243 n1 n240 inh_gnd inh_gnds inh_vdd inh_vdds) LVT_NOR2x1_PB4_AFBB
    U696 (n682 n683 n681 inh_gnd inh_gnds inh_vdd inh_vdds) LVT_NOR2x1_PB4_AFBB
    U697 (n124 n569 n683 inh_gnd inh_gnds inh_vdd inh_vdds) LVT_NOR2x1_PB4_AFBB
    U701 (n21 n572 n684 inh_gnd inh_gnds inh_vdd inh_vdds) LVT_NOR2x1_PB4_AFBB
    U700 (n190 n568 n685 inh_gnd inh_gnds inh_vdd inh_vdds) LVT_NOR2x1_PB4_AFBB
    U699 (n684 n685 n680 inh_gnd inh_gnds inh_vdd inh_vdds) LVT_NOR2x1_PB4_AFBB
    U698 (n214 n587 n682 inh_gnd inh_gnds inh_vdd inh_vdds) LVT_NOR2x1_PB4_AFBB
    U302 (n239 n50 n233 inh_gnd inh_gnds inh_vdd inh_vdds) LVT_NOR2x1_PB4_AFBB
    U704 (n689 n690 n688 inh_gnd inh_gnds inh_vdd inh_vdds) LVT_NOR2x1_PB4_AFBB
    U705 (n124 n593 n690 inh_gnd inh_gnds inh_vdd inh_vdds) LVT_NOR2x1_PB4_AFBB
    U709 (n21 n596 n691 inh_gnd inh_gnds inh_vdd inh_vdds) LVT_NOR2x1_PB4_AFBB
    U708 (n190 n592 n692 inh_gnd inh_gnds inh_vdd inh_vdds) LVT_NOR2x1_PB4_AFBB
    U707 (n691 n692 n687 inh_gnd inh_gnds inh_vdd inh_vdds) LVT_NOR2x1_PB4_AFBB
    U635 (n152 n105 n623 inh_gnd inh_gnds inh_vdd inh_vdds) LVT_NOR2x1_PB4_AFBB
    U706 (n152 n573 n689 inh_gnd inh_gnds inh_vdd inh_vdds) LVT_NOR2x1_PB4_AFBB
    U634 (n187 n61 n624 inh_gnd inh_gnds inh_vdd inh_vdds) LVT_NOR2x1_PB4_AFBB
    U633 (n623 n624 n622 inh_gnd inh_gnds inh_vdd inh_vdds) LVT_NOR2x1_PB4_AFBB
    U638 (n21 n99 n625 inh_gnd inh_gnds inh_vdd inh_vdds) LVT_NOR2x1_PB4_AFBB
    U637 (n190 n92 n626 inh_gnd inh_gnds inh_vdd inh_vdds) LVT_NOR2x1_PB4_AFBB
    U636 (n625 n626 n621 inh_gnd inh_gnds inh_vdd inh_vdds) LVT_NOR2x1_PB4_AFBB
    U382 (n211 n88 n354 inh_gnd inh_gnds inh_vdd inh_vdds) LVT_NOR2x1_PB4_AFBB
    U380 (n354 n355 n353 inh_gnd inh_gnds inh_vdd inh_vdds) LVT_NOR2x1_PB4_AFBB
    U381 (n186 n137 n355 inh_gnd inh_gnds inh_vdd inh_vdds) LVT_NOR2x1_PB4_AFBB
    U385 (n21 n95 n356 inh_gnd inh_gnds inh_vdd inh_vdds) LVT_NOR2x1_PB4_AFBB
    U384 (n190 n122 n357 inh_gnd inh_gnds inh_vdd inh_vdds) LVT_NOR2x1_PB4_AFBB
    U383 (n356 n357 n352 inh_gnd inh_gnds inh_vdd inh_vdds) LVT_NOR2x1_PB4_AFBB
    U486 (n464 n463 n457 inh_gnd inh_gnds inh_vdd inh_vdds) LVT_NOR2x1_PB4_AFBB
    U386 (n44 n358 n340 inh_gnd inh_gnds inh_vdd inh_vdds) LVT_NOR2x1_PB4_AFBB
    U487 (n196 n20 n464 inh_gnd inh_gnds inh_vdd inh_vdds) LVT_NOR2x1_PB4_AFBB
    U488 (n37 n200 n463 inh_gnd inh_gnds inh_vdd inh_vdds) LVT_NOR2x1_PB4_AFBB
    U517 (n202 n404 n492 inh_gnd inh_gnds inh_vdd inh_vdds) LVT_NOR2x1_PB4_AFBB
    U513 (n493 n492 n485 inh_gnd inh_gnds inh_vdd inh_vdds) LVT_NOR2x1_PB4_AFBB
    U512 (n58 n168 n487 inh_gnd inh_gnds inh_vdd inh_vdds) LVT_NOR2x1_PB4_AFBB
    U509 (n488 n487 n486 inh_gnd inh_gnds inh_vdd inh_vdds) LVT_NOR2x1_PB4_AFBB
    U506 (n202 n370 n483 inh_gnd inh_gnds inh_vdd inh_vdds) LVT_NOR2x1_PB4_AFBB
    U505 (n483 n482 n475 inh_gnd inh_gnds inh_vdd inh_vdds) LVT_NOR2x1_PB4_AFBB
    U594 (n575 n574 n550 inh_gnd inh_gnds inh_vdd inh_vdds) LVT_NOR2x1_PB4_AFBB
    U612 (n255 n208 n574 inh_gnd inh_gnds inh_vdd inh_vdds) LVT_NOR2x1_PB4_AFBB
    U586 (n252 n4 n552 inh_gnd inh_gnds inh_vdd inh_vdds) LVT_NOR2x1_PB4_AFBB
    U572 (n552 n553 n551 inh_gnd inh_gnds inh_vdd inh_vdds) LVT_NOR2x1_PB4_AFBB
    U484 (n58 n178 n460 inh_gnd inh_gnds inh_vdd inh_vdds) LVT_NOR2x1_PB4_AFBB
    U485 (n75 n337 n459 inh_gnd inh_gnds inh_vdd inh_vdds) LVT_NOR2x1_PB4_AFBB
    U483 (n459 n460 n458 inh_gnd inh_gnds inh_vdd inh_vdds) LVT_NOR2x1_PB4_AFBB
    U368 (n341 n340 n339 inh_gnd inh_gnds inh_vdd inh_vdds) LVT_NOR2x1_PB4_AFBB
    U389 (n203 n273 n360 inh_gnd inh_gnds inh_vdd inh_vdds) LVT_NOR2x1_PB4_AFBB
    U323 (n273 n182 n270 inh_gnd inh_gnds inh_vdd inh_vdds) LVT_NOR2x1_PB4_AFBB
    U388 (n272 n182 n361 inh_gnd inh_gnds inh_vdd inh_vdds) LVT_NOR2x1_PB4_AFBB
    U387 (n361 n360 n338 inh_gnd inh_gnds inh_vdd inh_vdds) LVT_NOR2x1_PB4_AFBB
    U318 (n264 n209 n263 inh_gnd inh_gnds inh_vdd inh_vdds) LVT_NOR2x1_PB4_AFBB
    U317 (n263 n262 n261 inh_gnd inh_gnds inh_vdd inh_vdds) LVT_NOR2x1_PB4_AFBB
    U375 (n349 n350 n345 inh_gnd inh_gnds inh_vdd inh_vdds) LVT_NOR2x1_PB4_AFBB
    U376 (n190 n49 n350 inh_gnd inh_gnds inh_vdd inh_vdds) LVT_NOR2x1_PB4_AFBB
    U374 (n213 n56 n347 inh_gnd inh_gnds inh_vdd inh_vdds) LVT_NOR2x1_PB4_AFBB
    U373 (n187 n97 n348 inh_gnd inh_gnds inh_vdd inh_vdds) LVT_NOR2x1_PB4_AFBB
    U372 (n348 n347 n346 inh_gnd inh_gnds inh_vdd inh_vdds) LVT_NOR2x1_PB4_AFBB
    U625 (n618 n617 n616 inh_gnd inh_gnds inh_vdd inh_vdds) LVT_NOR2x1_PB4_AFBB
    U626 (n124 n90 n618 inh_gnd inh_gnds inh_vdd inh_vdds) LVT_NOR2x1_PB4_AFBB
    U627 (n213 n26 n617 inh_gnd inh_gnds inh_vdd inh_vdds) LVT_NOR2x1_PB4_AFBB
    U628 (n620 n619 n615 inh_gnd inh_gnds inh_vdd inh_vdds) LVT_NOR2x1_PB4_AFBB
    U630 (n21 n141 n619 inh_gnd inh_gnds inh_vdd inh_vdds) LVT_NOR2x1_PB4_AFBB
    U629 (n190 n143 n620 inh_gnd inh_gnds inh_vdd inh_vdds) LVT_NOR2x1_PB4_AFBB
    U321 (n270 n271 n257 inh_gnd inh_gnds inh_vdd inh_vdds) LVT_NOR2x1_PB4_AFBB
    U322 (n272 n169 n271 inh_gnd inh_gnds inh_vdd inh_vdds) LVT_NOR2x1_PB4_AFBB
    U311 (n252 n2 n246 inh_gnd inh_gnds inh_vdd inh_vdds) LVT_NOR2x1_PB4_AFBB
    U366 (n209 n337 n336 inh_gnd inh_gnds inh_vdd inh_vdds) LVT_NOR2x1_PB4_AFBB
    U365 (n336 n74 n334 inh_gnd inh_gnds inh_vdd inh_vdds) LVT_NOR2x1_PB4_AFBB
    U662 (n647 n154 n643 inh_gnd inh_gnds inh_vdd inh_vdds) LVT_NOR2x1_PB4_AFBB
    U416 (n32 n395 n394 inh_gnd inh_gnds inh_vdd inh_vdds) LVT_NOR2x1_PB4_AFBB
    U663 (n32 n20 n647 inh_gnd inh_gnds inh_vdd inh_vdds) LVT_NOR2x1_PB4_AFBB
    U670 (n21 n70 n653 inh_gnd inh_gnds inh_vdd inh_vdds) LVT_NOR2x1_PB4_AFBB
    U669 (n190 n134 n654 inh_gnd inh_gnds inh_vdd inh_vdds) LVT_NOR2x1_PB4_AFBB
    U668 (n653 n654 n649 inh_gnd inh_gnds inh_vdd inh_vdds) LVT_NOR2x1_PB4_AFBB
    U667 (n41 n52 n651 inh_gnd inh_gnds inh_vdd inh_vdds) LVT_NOR2x1_PB4_AFBB
    U666 (n186 n562 n652 inh_gnd inh_gnds inh_vdd inh_vdds) LVT_NOR2x1_PB4_AFBB
    U665 (n651 n652 n650 inh_gnd inh_gnds inh_vdd inh_vdds) LVT_NOR2x1_PB4_AFBB
    U647 (n633 n634 n609 inh_gnd inh_gnds inh_vdd inh_vdds) LVT_NOR2x1_PB4_AFBB
    U621 (n612 n611 n610 inh_gnd inh_gnds inh_vdd inh_vdds) LVT_NOR2x1_PB4_AFBB
    U656 (n108 n642 n633 inh_gnd inh_gnds inh_vdd inh_vdds) LVT_NOR2x1_PB4_AFBB
    U650 (n638 n639 n637 inh_gnd inh_gnds inh_vdd inh_vdds) LVT_NOR2x1_PB4_AFBB
    U651 (n124 n30 n639 inh_gnd inh_gnds inh_vdd inh_vdds) LVT_NOR2x1_PB4_AFBB
    U648 (n207 n272 n634 inh_gnd inh_gnds inh_vdd inh_vdds) LVT_NOR2x1_PB4_AFBB
    U655 (n21 n139 n640 inh_gnd inh_gnds inh_vdd inh_vdds) LVT_NOR2x1_PB4_AFBB
    U654 (n190 n132 n641 inh_gnd inh_gnds inh_vdd inh_vdds) LVT_NOR2x1_PB4_AFBB
    U653 (n640 n641 n636 inh_gnd inh_gnds inh_vdd inh_vdds) LVT_NOR2x1_PB4_AFBB
    U616 (n214 n604 n601 inh_gnd inh_gnds inh_vdd inh_vdds) LVT_NOR2x1_PB4_AFBB
    U652 (n214 n28 n638 inh_gnd inh_gnds inh_vdd inh_vdds) LVT_NOR2x1_PB4_AFBB
    U641 (n629 n630 n628 inh_gnd inh_gnds inh_vdd inh_vdds) LVT_NOR2x1_PB4_AFBB
    U642 (n124 n130 n630 inh_gnd inh_gnds inh_vdd inh_vdds) LVT_NOR2x1_PB4_AFBB
    U639 (n273 n168 n611 inh_gnd inh_gnds inh_vdd inh_vdds) LVT_NOR2x1_PB4_AFBB
    U646 (n21 n68 n631 inh_gnd inh_gnds inh_vdd inh_vdds) LVT_NOR2x1_PB4_AFBB
    U645 (n190 n86 n632 inh_gnd inh_gnds inh_vdd inh_vdds) LVT_NOR2x1_PB4_AFBB
    U644 (n631 n632 n627 inh_gnd inh_gnds inh_vdd inh_vdds) LVT_NOR2x1_PB4_AFBB
    U643 (n41 n24 n629 inh_gnd inh_gnds inh_vdd inh_vdds) LVT_NOR2x1_PB4_AFBB
    U615 (n187 n29 n602 inh_gnd inh_gnds inh_vdd inh_vdds) LVT_NOR2x1_PB4_AFBB
    U313 (n255 n171 n254 inh_gnd inh_gnds inh_vdd inh_vdds) LVT_NOR2x1_PB4_AFBB
    U614 (n601 n602 n600 inh_gnd inh_gnds inh_vdd inh_vdds) LVT_NOR2x1_PB4_AFBB
    U619 (n21 n133 n605 inh_gnd inh_gnds inh_vdd inh_vdds) LVT_NOR2x1_PB4_AFBB
    U618 (n190 n31 n606 inh_gnd inh_gnds inh_vdd inh_vdds) LVT_NOR2x1_PB4_AFBB
    U617 (n605 n606 n599 inh_gnd inh_gnds inh_vdd inh_vdds) LVT_NOR2x1_PB4_AFBB
    U415 (n394 n155 n391 inh_gnd inh_gnds inh_vdd inh_vdds) LVT_NOR2x1_PB4_AFBB
    U671 (n48 n655 n380 inh_gnd inh_gnds inh_vdd inh_vdds) LVT_NOR2x1_PB4_AFBB
    U588 (n567 n566 n565 inh_gnd inh_gnds inh_vdd inh_vdds) LVT_NOR2x1_PB4_AFBB
    U590 (n151 n100 n566 inh_gnd inh_gnds inh_vdd inh_vdds) LVT_NOR2x1_PB4_AFBB
    U593 (n21 n144 n570 inh_gnd inh_gnds inh_vdd inh_vdds) LVT_NOR2x1_PB4_AFBB
    U592 (n190 n91 n571 inh_gnd inh_gnds inh_vdd inh_vdds) LVT_NOR2x1_PB4_AFBB
    U591 (n570 n571 n564 inh_gnd inh_gnds inh_vdd inh_vdds) LVT_NOR2x1_PB4_AFBB
    U589 (n186 n27 n567 inh_gnd inh_gnds inh_vdd inh_vdds) LVT_NOR2x1_PB4_AFBB
    U501 (n477 n478 n476 inh_gnd inh_gnds inh_vdd inh_vdds) LVT_NOR2x1_PB4_AFBB
    U504 (n395 n183 n477 inh_gnd inh_gnds inh_vdd inh_vdds) LVT_NOR2x1_PB4_AFBB
    U689 (n10 n656 n674 inh_gnd inh_gnds inh_vdd inh_vdds) LVT_NOR2x1_PB4_AFBB
    U688 (n124 n507 n675 inh_gnd inh_gnds inh_vdd inh_vdds) LVT_NOR2x1_PB4_AFBB
    U687 (n674 n675 n673 inh_gnd inh_gnds inh_vdd inh_vdds) LVT_NOR2x1_PB4_AFBB
    U718 (n198 B\<4\> n281 inh_gnd inh_gnds inh_vdd inh_vdds) LVT_NOR2x1_PB4_AFBB
    U393 (n209 n367 n366 inh_gnd inh_gnds inh_vdd inh_vdds) LVT_NOR2x1_PB4_AFBB
    U392 (n366 n74 n365 inh_gnd inh_gnds inh_vdd inh_vdds) LVT_NOR2x1_PB4_AFBB
    U359 (n190 n327 n326 inh_gnd inh_gnds inh_vdd inh_vdds) LVT_NOR2x1_PB4_AFBB
    U360 (n21 n328 n325 inh_gnd inh_gnds inh_vdd inh_vdds) LVT_NOR2x1_PB4_AFBB
    U355 (n322 n321 n320 inh_gnd inh_gnds inh_vdd inh_vdds) LVT_NOR2x1_PB4_AFBB
    U357 (n212 n140 n321 inh_gnd inh_gnds inh_vdd inh_vdds) LVT_NOR2x1_PB4_AFBB
    U358 (n325 n326 n319 inh_gnd inh_gnds inh_vdd inh_vdds) LVT_NOR2x1_PB4_AFBB
    U579 (n559 n558 n557 inh_gnd inh_gnds inh_vdd inh_vdds) LVT_NOR2x1_PB4_AFBB
    U581 (n212 n63 n558 inh_gnd inh_gnds inh_vdd inh_vdds) LVT_NOR2x1_PB4_AFBB
    U580 (n186 n53 n559 inh_gnd inh_gnds inh_vdd inh_vdds) LVT_NOR2x1_PB4_AFBB
    U584 (n21 n135 n560 inh_gnd inh_gnds inh_vdd inh_vdds) LVT_NOR2x1_PB4_AFBB
    U583 (n190 n66 n561 inh_gnd inh_gnds inh_vdd inh_vdds) LVT_NOR2x1_PB4_AFBB
    U582 (n560 n561 n556 inh_gnd inh_gnds inh_vdd inh_vdds) LVT_NOR2x1_PB4_AFBB
    U394 (n369 n73 n368 inh_gnd inh_gnds inh_vdd inh_vdds) LVT_NOR2x1_PB4_AFBB
    U395 (n13 n34 n369 inh_gnd inh_gnds inh_vdd inh_vdds) LVT_NOR2x1_PB4_AFBB
    U356 (n124 n89 n322 inh_gnd inh_gnds inh_vdd inh_vdds) LVT_NOR2x1_PB4_AFBB
    U307 (n246 n247 n245 inh_gnd inh_gnds inh_vdd inh_vdds) LVT_NOR2x1_PB4_AFBB
    U312 (n253 n254 n244 inh_gnd inh_gnds inh_vdd inh_vdds) LVT_NOR2x1_PB4_AFBB
    U314 (n256 n183 n253 inh_gnd inh_gnds inh_vdd inh_vdds) LVT_NOR2x1_PB4_AFBB
    U606 (n590 n591 n589 inh_gnd inh_gnds inh_vdd inh_vdds) LVT_NOR2x1_PB4_AFBB
    U607 (n187 n25 n591 inh_gnd inh_gnds inh_vdd inh_vdds) LVT_NOR2x1_PB4_AFBB
    U611 (n21 n87 n594 inh_gnd inh_gnds inh_vdd inh_vdds) LVT_NOR2x1_PB4_AFBB
    U610 (n190 n131 n595 inh_gnd inh_gnds inh_vdd inh_vdds) LVT_NOR2x1_PB4_AFBB
    U609 (n594 n595 n588 inh_gnd inh_gnds inh_vdd inh_vdds) LVT_NOR2x1_PB4_AFBB
    U600 (n41 n69 n580 inh_gnd inh_gnds inh_vdd inh_vdds) LVT_NOR2x1_PB4_AFBB
    U608 (n151 n142 n590 inh_gnd inh_gnds inh_vdd inh_vdds) LVT_NOR2x1_PB4_AFBB
    U603 (n21 n93 n584 inh_gnd inh_gnds inh_vdd inh_vdds) LVT_NOR2x1_PB4_AFBB
    U602 (n190 n62 n585 inh_gnd inh_gnds inh_vdd inh_vdds) LVT_NOR2x1_PB4_AFBB
    U601 (n585 n584 n578 inh_gnd inh_gnds inh_vdd inh_vdds) LVT_NOR2x1_PB4_AFBB
    U599 (n187 n582 n581 inh_gnd inh_gnds inh_vdd inh_vdds) LVT_NOR2x1_PB4_AFBB
    U598 (n580 n581 n579 inh_gnd inh_gnds inh_vdd inh_vdds) LVT_NOR2x1_PB4_AFBB
    U692 (n21 n65 n676 inh_gnd inh_gnds inh_vdd inh_vdds) LVT_NOR2x1_PB4_AFBB
    U690 (n676 n677 n672 inh_gnd inh_gnds inh_vdd inh_vdds) LVT_NOR2x1_PB4_AFBB
    U691 (n190 n54 n677 inh_gnd inh_gnds inh_vdd inh_vdds) LVT_NOR2x1_PB4_AFBB
    U507 (n256 n207 n482 inh_gnd inh_gnds inh_vdd inh_vdds) LVT_NOR2x1_PB4_AFBB
    U660 (A\<31\> n21 n646 inh_gnd inh_gnds inh_vdd inh_vdds) LVT_NADN2x1_PB4_AFBB
    U661 (A\<30\> n111 n645 inh_gnd inh_gnds inh_vdd inh_vdds) LVT_NADN2x1_PB4_AFBB
    U659 (n645 n646 n462 inh_gnd inh_gnds inh_vdd inh_vdds) LVT_NADN2x1_PB4_AFBB
    U541 (A\<25\> n111 n522 inh_gnd inh_gnds inh_vdd inh_vdds) LVT_NADN2x1_PB4_AFBB
    U540 (A\<26\> n42 n523 inh_gnd inh_gnds inh_vdd inh_vdds) LVT_NADN2x1_PB4_AFBB
    U539 (n522 n523 n521 inh_gnd inh_gnds inh_vdd inh_vdds) LVT_NADN2x1_PB4_AFBB
    U544 (A\<28\> n60 n524 inh_gnd inh_gnds inh_vdd inh_vdds) LVT_NADN2x1_PB4_AFBB
    U543 (A\<27\> n185 n525 inh_gnd inh_gnds inh_vdd inh_vdds) LVT_NADN2x1_PB4_AFBB
    U542 (n524 n525 n520 inh_gnd inh_gnds inh_vdd inh_vdds) LVT_NADN2x1_PB4_AFBB
    U678 (n666 n667 n549 inh_gnd inh_gnds inh_vdd inh_vdds) LVT_NADN2x1_PB4_AFBB
    U752 (B\<1\> B\<0\> n313 inh_gnd inh_gnds inh_vdd inh_vdds) LVT_NADN2x1_PB4_AFBB
    U753 (A\<2\> n185 n722 inh_gnd inh_gnds inh_vdd inh_vdds) LVT_NADN2x1_PB4_AFBB
    U751 (A\<3\> n60 n723 inh_gnd inh_gnds inh_vdd inh_vdds) LVT_NADN2x1_PB4_AFBB
    U750 (n722 n723 n717 inh_gnd inh_gnds inh_vdd inh_vdds) LVT_NADN2x1_PB4_AFBB
    U748 (A\<1\> n42 n719 inh_gnd inh_gnds inh_vdd inh_vdds) LVT_NADN2x1_PB4_AFBB
    U747 (A\<0\> n110 n720 inh_gnd inh_gnds inh_vdd inh_vdds) LVT_NADN2x1_PB4_AFBB
    U746 (n719 n720 n718 inh_gnd inh_gnds inh_vdd inh_vdds) LVT_NADN2x1_PB4_AFBB
    U730 (B\<2\> B\<3\> n461 inh_gnd inh_gnds inh_vdd inh_vdds) LVT_NADN2x1_PB4_AFBB
    U721 (n543 n166 n700 inh_gnd inh_gnds inh_vdd inh_vdds) LVT_NADN2x1_PB4_AFBB
    U720 (n699 n700 n658 inh_gnd inh_gnds inh_vdd inh_vdds) LVT_NADN2x1_PB4_AFBB
    U674 (B\<4\> n474 n661 inh_gnd inh_gnds inh_vdd inh_vdds) LVT_NADN2x1_PB4_AFBB
    U710 (n157 n7 n660 inh_gnd inh_gnds inh_vdd inh_vdds) LVT_NADN2x1_PB4_AFBB
    U673 (n660 n661 n659 inh_gnd inh_gnds inh_vdd inh_vdds) LVT_NADN2x1_PB4_AFBB
    U548 (A\<18\> n42 n529 inh_gnd inh_gnds inh_vdd inh_vdds) LVT_NADN2x1_PB4_AFBB
    U549 (n5 A\<17\> n528 inh_gnd inh_gnds inh_vdd inh_vdds) LVT_NADN2x1_PB4_AFBB
    U547 (n528 n529 n527 inh_gnd inh_gnds inh_vdd inh_vdds) LVT_NADN2x1_PB4_AFBB
    U551 (A\<19\> n185 n531 inh_gnd inh_gnds inh_vdd inh_vdds) LVT_NADN2x1_PB4_AFBB
    U552 (A\<20\> n162 n530 inh_gnd inh_gnds inh_vdd inh_vdds) LVT_NADN2x1_PB4_AFBB
    U448 (A\<4\> n162 n428 inh_gnd inh_gnds inh_vdd inh_vdds) LVT_NADN2x1_PB4_AFBB
    U550 (n530 n531 n526 inh_gnd inh_gnds inh_vdd inh_vdds) LVT_NADN2x1_PB4_AFBB
    U557 (n5 A\<13\> n534 inh_gnd inh_gnds inh_vdd inh_vdds) LVT_NADN2x1_PB4_AFBB
    U556 (A\<14\> n191 n535 inh_gnd inh_gnds inh_vdd inh_vdds) LVT_NADN2x1_PB4_AFBB
    U555 (n534 n535 n533 inh_gnd inh_gnds inh_vdd inh_vdds) LVT_NADN2x1_PB4_AFBB
    U559 (A\<15\> n185 n537 inh_gnd inh_gnds inh_vdd inh_vdds) LVT_NADN2x1_PB4_AFBB
    U560 (A\<16\> n163 n536 inh_gnd inh_gnds inh_vdd inh_vdds) LVT_NADN2x1_PB4_AFBB
    U459 (A\<12\> n163 n437 inh_gnd inh_gnds inh_vdd inh_vdds) LVT_NADN2x1_PB4_AFBB
    U558 (n536 n537 n532 inh_gnd inh_gnds inh_vdd inh_vdds) LVT_NADN2x1_PB4_AFBB
    U534 (A\<24\> n60 n513 inh_gnd inh_gnds inh_vdd inh_vdds) LVT_NADN2x1_PB4_AFBB
    U533 (A\<23\> n185 n514 inh_gnd inh_gnds inh_vdd inh_vdds) LVT_NADN2x1_PB4_AFBB
    U532 (n513 n514 n509 inh_gnd inh_gnds inh_vdd inh_vdds) LVT_NADN2x1_PB4_AFBB
    U531 (n111 A\<21\> n511 inh_gnd inh_gnds inh_vdd inh_vdds) LVT_NADN2x1_PB4_AFBB
    U530 (A\<22\> n191 n512 inh_gnd inh_gnds inh_vdd inh_vdds) LVT_NADN2x1_PB4_AFBB
    U529 (n511 n512 n510 inh_gnd inh_gnds inh_vdd inh_vdds) LVT_NADN2x1_PB4_AFBB
    U455 (A\<10\> n191 n436 inh_gnd inh_gnds inh_vdd inh_vdds) LVT_NADN2x1_PB4_AFBB
    U456 (n110 A\<9\> n435 inh_gnd inh_gnds inh_vdd inh_vdds) LVT_NADN2x1_PB4_AFBB
    U454 (n435 n436 n434 inh_gnd inh_gnds inh_vdd inh_vdds) LVT_NADN2x1_PB4_AFBB
    U458 (A\<11\> n185 n438 inh_gnd inh_gnds inh_vdd inh_vdds) LVT_NADN2x1_PB4_AFBB
    U457 (n437 n438 n433 inh_gnd inh_gnds inh_vdd inh_vdds) LVT_NADN2x1_PB4_AFBB
    U451 (A\<1\> n110 n430 inh_gnd inh_gnds inh_vdd inh_vdds) LVT_NADN2x1_PB4_AFBB
    U450 (A\<2\> n432 n431 inh_gnd inh_gnds inh_vdd inh_vdds) LVT_NADN2x1_PB4_AFBB
    U449 (n430 n431 n426 inh_gnd inh_gnds inh_vdd inh_vdds) LVT_NADN2x1_PB4_AFBB
    U447 (A\<3\> n185 n429 inh_gnd inh_gnds inh_vdd inh_vdds) LVT_NADN2x1_PB4_AFBB
    U446 (n428 n429 n427 inh_gnd inh_gnds inh_vdd inh_vdds) LVT_NADN2x1_PB4_AFBB
    U442 (n421 n422 n420 inh_gnd inh_gnds inh_vdd inh_vdds) LVT_NADN2x1_PB4_AFBB
    U441 (n418 n419 sra_res\<1\> inh_gnd inh_gnds inh_vdd inh_vdds) LVT_NADN2x1_PB4_AFBB
    U460 (n6 n157 n421 inh_gnd inh_gnds inh_vdd inh_vdds) LVT_NADN2x1_PB4_AFBB
    U470 (B\<4\> n448 n447 inh_gnd inh_gnds inh_vdd inh_vdds) LVT_NADN2x1_PB4_AFBB
    U576 (B\<2\> A\<31\> n555 inh_gnd inh_gnds inh_vdd inh_vdds) LVT_NADN2x1_PB4_AFBB
    U575 (n153 n555 n372 inh_gnd inh_gnds inh_vdd inh_vdds) LVT_NADN2x1_PB4_AFBB
    U754 (B\<1\> n721 n311 inh_gnd inh_gnds inh_vdd inh_vdds) LVT_NADN2x1_PB4_AFBB
    U523 (B\<1\> A\<31\> n504 inh_gnd inh_gnds inh_vdd inh_vdds) LVT_NADN2x1_PB4_AFBB
    U522 (n504 n503 n379 inh_gnd inh_gnds inh_vdd inh_vdds) LVT_NADN2x1_PB4_AFBB
    U480 (n456 n174 sra_res\<18\> inh_gnd inh_gnds inh_vdd inh_vdds) LVT_NADN2x1_PB4_AFBB
    U481 (n11 n330 n456 inh_gnd inh_gnds inh_vdd inh_vdds) LVT_NADN2x1_PB4_AFBB
    U489 (n466 n174 sra_res\<17\> inh_gnd inh_gnds inh_vdd inh_vdds) LVT_NADN2x1_PB4_AFBB
    U491 (n467 n468 n448 inh_gnd inh_gnds inh_vdd inh_vdds) LVT_NADN2x1_PB4_AFBB
    U490 (n204 n448 n466 inh_gnd inh_gnds inh_vdd inh_vdds) LVT_NADN2x1_PB4_AFBB
    U97 (B\<2\> B\<3\> n76 inh_gnd inh_gnds inh_vdd inh_vdds) LVT_NADN2x1_PB4_AFBB
    U397 (n373 n174 sra_res\<26\> inh_gnd inh_gnds inh_vdd inh_vdds) LVT_NADN2x1_PB4_AFBB
    U398 (n8 n109 n373 inh_gnd inh_gnds inh_vdd inh_vdds) LVT_NADN2x1_PB4_AFBB
    U427 (n407 n408 n280 inh_gnd inh_gnds inh_vdd inh_vdds) LVT_NADN2x1_PB4_AFBB
    U327 (B\<4\> n280 n279 inh_gnd inh_gnds inh_vdd inh_vdds) LVT_NADN2x1_PB4_AFBB
    U328 (n159 n223 n278 inh_gnd inh_gnds inh_vdd inh_vdds) LVT_NADN2x1_PB4_AFBB
    U292 (n127 n223 n219 inh_gnd inh_gnds inh_vdd inh_vdds) LVT_NADN2x1_PB4_AFBB
    U290 (n219 n220 n218 inh_gnd inh_gnds inh_vdd inh_vdds) LVT_NADN2x1_PB4_AFBB
    U291 (B\<4\> n221 n220 inh_gnd inh_gnds inh_vdd inh_vdds) LVT_NADN2x1_PB4_AFBB
    U324 (n274 n275 sra_res\<5\> inh_gnd inh_gnds inh_vdd inh_vdds) LVT_NADN2x1_PB4_AFBB
    U326 (n278 n279 n277 inh_gnd inh_gnds inh_vdd inh_vdds) LVT_NADN2x1_PB4_AFBB
    U461 (n439 n440 n284 inh_gnd inh_gnds inh_vdd inh_vdds) LVT_NADN2x1_PB4_AFBB
    U518 (n498 n499 sra_res\<13\> inh_gnd inh_gnds inh_vdd inh_vdds) LVT_NADN2x1_PB4_AFBB
    U520 (n189 n502 n501 inh_gnd inh_gnds inh_vdd inh_vdds) LVT_NADN2x1_PB4_AFBB
    U521 (n150 n23 n502 inh_gnd inh_gnds inh_vdd inh_vdds) LVT_NADN2x1_PB4_AFBB
    U288 (n215 n216 sra_res\<9\> inh_gnd inh_gnds inh_vdd inh_vdds) LVT_NADN2x1_PB4_AFBB
    U425 (n406 n174 sra_res\<21\> inh_gnd inh_gnds inh_vdd inh_vdds) LVT_NADN2x1_PB4_AFBB
    U426 (n16 n280 n406 inh_gnd inh_gnds inh_vdd inh_vdds) LVT_NADN2x1_PB4_AFBB
    U417 (n396 n174 sra_res\<22\> inh_gnd inh_gnds inh_vdd inh_vdds) LVT_NADN2x1_PB4_AFBB
    U418 (n47 n267 n396 inh_gnd inh_gnds inh_vdd inh_vdds) LVT_NADN2x1_PB4_AFBB
    U411 (n390 n174 sra_res\<23\> inh_gnd inh_gnds inh_vdd inh_vdds) LVT_NADN2x1_PB4_AFBB
    U412 (n106 n251 n390 inh_gnd inh_gnds inh_vdd inh_vdds) LVT_NADN2x1_PB4_AFBB
    U399 (n375 n174 sra_res\<25\> inh_gnd inh_gnds inh_vdd inh_vdds) LVT_NADN2x1_PB4_AFBB
    U400 (n18 n221 n375 inh_gnd inh_gnds inh_vdd inh_vdds) LVT_NADN2x1_PB4_AFBB
    U401 (n376 n377 n221 inh_gnd inh_gnds inh_vdd inh_vdds) LVT_NADN2x1_PB4_AFBB
    U402 (n378 n23 n377 inh_gnd inh_gnds inh_vdd inh_vdds) LVT_NADN2x1_PB4_AFBB
    U471 (n449 n175 sra_res\<19\> inh_gnd inh_gnds inh_vdd inh_vdds) LVT_NADN2x1_PB4_AFBB
    U472 (n9 n205 n449 inh_gnd inh_gnds inh_vdd inh_vdds) LVT_NADN2x1_PB4_AFBB
    U498 (n175 n473 sra_res\<16\> inh_gnd inh_gnds inh_vdd inh_vdds) LVT_NADN2x1_PB4_AFBB
    U675 (n662 n663 n474 inh_gnd inh_gnds inh_vdd inh_vdds) LVT_NADN2x1_PB4_AFBB
    U499 (n15 n474 n473 inh_gnd inh_gnds inh_vdd inh_vdds) LVT_NADN2x1_PB4_AFBB
    U98 (B\<2\> B\<3\> n77 inh_gnd inh_gnds inh_vdd inh_vdds) LVT_NADN2x1_PB4_AFBB
    U473 (n451 n450 n331 inh_gnd inh_gnds inh_vdd inh_vdds) LVT_NADN2x1_PB4_AFBB
    U342 (n300 n301 sra_res\<3\> inh_gnd inh_gnds inh_vdd inh_vdds) LVT_NADN2x1_PB4_AFBB
    U353 (n158 n250 n304 inh_gnd inh_gnds inh_vdd inh_vdds) LVT_NADN2x1_PB4_AFBB
    U338 (n51 n158 n290 inh_gnd inh_gnds inh_vdd inh_vdds) LVT_NADN2x1_PB4_AFBB
    U345 (n127 n306 n305 inh_gnd inh_gnds inh_vdd inh_vdds) LVT_NADN2x1_PB4_AFBB
    U346 (n307 n308 n306 inh_gnd inh_gnds inh_vdd inh_vdds) LVT_NADN2x1_PB4_AFBB
    U344 (n304 n305 n303 inh_gnd inh_gnds inh_vdd inh_vdds) LVT_NADN2x1_PB4_AFBB
    U435 (n413 n414 n295 inh_gnd inh_gnds inh_vdd inh_vdds) LVT_NADN2x1_PB4_AFBB
    U711 (n693 n694 n297 inh_gnd inh_gnds inh_vdd inh_vdds) LVT_NADN2x1_PB4_AFBB
    U336 (B\<4\> n295 n294 inh_gnd inh_gnds inh_vdd inh_vdds) LVT_NADN2x1_PB4_AFBB
    U333 (n287 n288 sra_res\<4\> inh_gnd inh_gnds inh_vdd inh_vdds) LVT_NADN2x1_PB4_AFBB
    U334 (n290 n291 n289 inh_gnd inh_gnds inh_vdd inh_vdds) LVT_NADN2x1_PB4_AFBB
    U419 (n397 n398 n267 inh_gnd inh_gnds inh_vdd inh_vdds) LVT_NADN2x1_PB4_AFBB
    U319 (B\<4\> n267 n266 inh_gnd inh_gnds inh_vdd inh_vdds) LVT_NADN2x1_PB4_AFBB
    U744 (n128 n84 n383 inh_gnd inh_gnds inh_vdd inh_vdds) LVT_NADN2x1_PB4_AFBB
    U433 (n175 n412 sra_res\<20\> inh_gnd inh_gnds inh_vdd inh_vdds) LVT_NADN2x1_PB4_AFBB
    U434 (n107 n295 n412 inh_gnd inh_gnds inh_vdd inh_vdds) LVT_NADN2x1_PB4_AFBB
    U405 (n384 n175 sra_res\<24\> inh_gnd inh_gnds inh_vdd inh_vdds) LVT_NADN2x1_PB4_AFBB
    U406 (n17 n237 n384 inh_gnd inh_gnds inh_vdd inh_vdds) LVT_NADN2x1_PB4_AFBB
    U301 (n51 n126 n235 inh_gnd inh_gnds inh_vdd inh_vdds) LVT_NADN2x1_PB4_AFBB
    U299 (n235 n236 n234 inh_gnd inh_gnds inh_vdd inh_vdds) LVT_NADN2x1_PB4_AFBB
    U735 (n710 n711 n238 inh_gnd inh_gnds inh_vdd inh_vdds) LVT_NADN2x1_PB4_AFBB
    U407 (n386 n385 n237 inh_gnd inh_gnds inh_vdd inh_vdds) LVT_NADN2x1_PB4_AFBB
    U408 (n378 n36 n386 inh_gnd inh_gnds inh_vdd inh_vdds) LVT_NADN2x1_PB4_AFBB
    U300 (B\<4\> n237 n236 inh_gnd inh_gnds inh_vdd inh_vdds) LVT_NADN2x1_PB4_AFBB
    U569 (n146 n549 n546 inh_gnd inh_gnds inh_vdd inh_vdds) LVT_NADN2x1_PB4_AFBB
    U567 (n546 n547 n545 inh_gnd inh_gnds inh_vdd inh_vdds) LVT_NADN2x1_PB4_AFBB
    U568 (n102 n548 n547 inh_gnd inh_gnds inh_vdd inh_vdds) LVT_NADN2x1_PB4_AFBB
    U561 (n538 n539 sra_res\<12\> inh_gnd inh_gnds inh_vdd inh_vdds) LVT_NADN2x1_PB4_AFBB
    U564 (n150 n36 n542 inh_gnd inh_gnds inh_vdd inh_vdds) LVT_NADN2x1_PB4_AFBB
    U563 (n189 n542 n541 inh_gnd inh_gnds inh_vdd inh_vdds) LVT_NADN2x1_PB4_AFBB
    U297 (n231 n232 sra_res\<8\> inh_gnd inh_gnds inh_vdd inh_vdds) LVT_NADN2x1_PB4_AFBB
    U722 (n701 n702 n543 inh_gnd inh_gnds inh_vdd inh_vdds) LVT_NADN2x1_PB4_AFBB
    U695 (n680 n681 n548 inh_gnd inh_gnds inh_vdd inh_vdds) LVT_NADN2x1_PB4_AFBB
    U703 (n687 n688 n686 inh_gnd inh_gnds inh_vdd inh_vdds) LVT_NADN2x1_PB4_AFBB
    U632 (n621 n622 n465 inh_gnd inh_gnds inh_vdd inh_vdds) LVT_NADN2x1_PB4_AFBB
    U379 (n352 n353 n265 inh_gnd inh_gnds inh_vdd inh_vdds) LVT_NADN2x1_PB4_AFBB
    U631 (n38 n146 n613 inh_gnd inh_gnds inh_vdd inh_vdds) LVT_NADN2x1_PB4_AFBB
    U622 (n613 n614 n612 inh_gnd inh_gnds inh_vdd inh_vdds) LVT_NADN2x1_PB4_AFBB
    U623 (n59 n102 n614 inh_gnd inh_gnds inh_vdd inh_vdds) LVT_NADN2x1_PB4_AFBB
    U482 (n457 n458 n359 inh_gnd inh_gnds inh_vdd inh_vdds) LVT_NADN2x1_PB4_AFBB
    U734 (B\<3\> n129 n403 inh_gnd inh_gnds inh_vdd inh_vdds) LVT_NADN2x1_PB4_AFBB
    U515 (n38 n181 n495 inh_gnd inh_gnds inh_vdd inh_vdds) LVT_NADN2x1_PB4_AFBB
    U514 (n494 n495 n493 inh_gnd inh_gnds inh_vdd inh_vdds) LVT_NADN2x1_PB4_AFBB
    U516 (n127 n497 n494 inh_gnd inh_gnds inh_vdd inh_vdds) LVT_NADN2x1_PB4_AFBB
    U508 (n485 n486 sra_res\<14\> inh_gnd inh_gnds inh_vdd inh_vdds) LVT_NADN2x1_PB4_AFBB
    U510 (n189 n489 n488 inh_gnd inh_gnds inh_vdd inh_vdds) LVT_NADN2x1_PB4_AFBB
    U511 (n150 n40 n489 inh_gnd inh_gnds inh_vdd inh_vdds) LVT_NADN2x1_PB4_AFBB
    U573 (n189 n554 n553 inh_gnd inh_gnds inh_vdd inh_vdds) LVT_NADN2x1_PB4_AFBB
    U500 (n475 n476 sra_res\<15\> inh_gnd inh_gnds inh_vdd inh_vdds) LVT_NADN2x1_PB4_AFBB
    U577 (n150 n14 n554 inh_gnd inh_gnds inh_vdd inh_vdds) LVT_NADN2x1_PB4_AFBB
    U571 (n550 n551 sra_res\<11\> inh_gnd inh_gnds inh_vdd inh_vdds) LVT_NADN2x1_PB4_AFBB
    U604 (n158 n484 n576 inh_gnd inh_gnds inh_vdd inh_vdds) LVT_NADN2x1_PB4_AFBB
    U596 (n166 n481 n577 inh_gnd inh_gnds inh_vdd inh_vdds) LVT_NADN2x1_PB4_AFBB
    U595 (n576 n577 n575 inh_gnd inh_gnds inh_vdd inh_vdds) LVT_NADN2x1_PB4_AFBB
    U96 (B\<2\> B\<3\> n75 inh_gnd inh_gnds inh_vdd inh_vdds) LVT_NADN2x1_PB4_AFBB
    U367 (n338 n339 sra_res\<2\> inh_gnd inh_gnds inh_vdd inh_vdds) LVT_NADN2x1_PB4_AFBB
    U369 (n342 n343 n341 inh_gnd inh_gnds inh_vdd inh_vdds) LVT_NADN2x1_PB4_AFBB
    U378 (n12 n157 n342 inh_gnd inh_gnds inh_vdd inh_vdds) LVT_NADN2x1_PB4_AFBB
    U371 (n345 n346 n344 inh_gnd inh_gnds inh_vdd inh_vdds) LVT_NADN2x1_PB4_AFBB
    U370 (n344 n126 n343 inh_gnd inh_gnds inh_vdd inh_vdds) LVT_NADN2x1_PB4_AFBB
    U624 (n615 n616 n268 inh_gnd inh_gnds inh_vdd inh_vdds) LVT_NADN2x1_PB4_AFBB
    U320 (n59 n166 n260 inh_gnd inh_gnds inh_vdd inh_vdds) LVT_NADN2x1_PB4_AFBB
    U315 (n258 n257 sra_res\<6\> inh_gnd inh_gnds inh_vdd inh_vdds) LVT_NADN2x1_PB4_AFBB
    U316 (n260 n261 n259 inh_gnd inh_gnds inh_vdd inh_vdds) LVT_NADN2x1_PB4_AFBB
    U574 (B\<4\> n83 n490 inh_gnd inh_gnds inh_vdd inh_vdds) LVT_NADN2x1_PB4_AFBB
    U396 (n147 n371 n335 inh_gnd inh_gnds inh_vdd inh_vdds) LVT_NADN2x1_PB4_AFBB
    U658 (n160 n40 n644 inh_gnd inh_gnds inh_vdd inh_vdds) LVT_NADN2x1_PB4_AFBB
    U657 (n644 n643 n374 inh_gnd inh_gnds inh_vdd inh_vdds) LVT_NADN2x1_PB4_AFBB
    U664 (n649 n650 n648 inh_gnd inh_gnds inh_vdd inh_vdds) LVT_NADN2x1_PB4_AFBB
    U620 (n609 n610 sra_res\<10\> inh_gnd inh_gnds inh_vdd inh_vdds) LVT_NADN2x1_PB4_AFBB
    U649 (n636 n637 n635 inh_gnd inh_gnds inh_vdd inh_vdds) LVT_NADN2x1_PB4_AFBB
    U640 (n627 n628 n497 inh_gnd inh_gnds inh_vdd inh_vdds) LVT_NADN2x1_PB4_AFBB
    U613 (n599 n600 n598 inh_gnd inh_gnds inh_vdd inh_vdds) LVT_NADN2x1_PB4_AFBB
    U413 (n392 n391 n251 inh_gnd inh_gnds inh_vdd inh_vdds) LVT_NADN2x1_PB4_AFBB
    U310 (B\<4\> n251 n248 inh_gnd inh_gnds inh_vdd inh_vdds) LVT_NADN2x1_PB4_AFBB
    U414 (n378 n14 n392 inh_gnd inh_gnds inh_vdd inh_vdds) LVT_NADN2x1_PB4_AFBB
    U587 (n564 n565 n480 inh_gnd inh_gnds inh_vdd inh_vdds) LVT_NADN2x1_PB4_AFBB
    U503 (n159 n480 n479 inh_gnd inh_gnds inh_vdd inh_vdds) LVT_NADN2x1_PB4_AFBB
    U183 (B\<4\> A\<31\> n147 inh_gnd inh_gnds inh_vdd inh_vdds) LVT_NADN2x1_PB4_AFBB
    U502 (n479 n175 n478 inh_gnd inh_gnds inh_vdd inh_vdds) LVT_NADN2x1_PB4_AFBB
    U18 (B\<1\> B\<0\> n10 inh_gnd inh_gnds inh_vdd inh_vdds) LVT_NADN2x1_PB4_AFBB
    U686 (n672 n673 n387 inh_gnd inh_gnds inh_vdd inh_vdds) LVT_NADN2x1_PB4_AFBB
    U719 (B\<2\> n85 n405 inh_gnd inh_gnds inh_vdd inh_vdds) LVT_NADN2x1_PB4_AFBB
    U354 (n319 n320 n250 inh_gnd inh_gnds inh_vdd inh_vdds) LVT_NADN2x1_PB4_AFBB
    U578 (n556 n557 n393 inh_gnd inh_gnds inh_vdd inh_vdds) LVT_NADN2x1_PB4_AFBB
    U308 (n248 n249 n247 inh_gnd inh_gnds inh_vdd inh_vdds) LVT_NADN2x1_PB4_AFBB
    U309 (n126 n250 n249 inh_gnd inh_gnds inh_vdd inh_vdds) LVT_NADN2x1_PB4_AFBB
    U306 (n244 n245 sra_res\<7\> inh_gnd inh_gnds inh_vdd inh_vdds) LVT_NADN2x1_PB4_AFBB
    U605 (n588 n589 n484 inh_gnd inh_gnds inh_vdd inh_vdds) LVT_NADN2x1_PB4_AFBB
    U597 (n578 n579 n481 inh_gnd inh_gnds inh_vdd inh_vdds) LVT_NADN2x1_PB4_AFBB
    Thru31 (sra_res\<0\> C\<0\>) iprobe
    Thru30 (sra_res\<1\> C\<1\>) iprobe
    Thru29 (sra_res\<2\> C\<2\>) iprobe
    Thru28 (sra_res\<3\> C\<3\>) iprobe
    Thru27 (sra_res\<4\> C\<4\>) iprobe
    Thru26 (sra_res\<5\> C\<5\>) iprobe
    Thru25 (sra_res\<6\> C\<6\>) iprobe
    Thru24 (sra_res\<7\> C\<7\>) iprobe
    Thru23 (sra_res\<8\> C\<8\>) iprobe
    Thru22 (sra_res\<9\> C\<9\>) iprobe
    Thru21 (sra_res\<10\> C\<10\>) iprobe
    Thru20 (sra_res\<11\> C\<11\>) iprobe
    Thru19 (sra_res\<12\> C\<12\>) iprobe
    Thru18 (sra_res\<13\> C\<13\>) iprobe
    Thru17 (sra_res\<14\> C\<14\>) iprobe
    Thru16 (sra_res\<15\> C\<15\>) iprobe
    Thru15 (sra_res\<16\> C\<16\>) iprobe
    Thru14 (sra_res\<17\> C\<17\>) iprobe
    Thru13 (sra_res\<18\> C\<18\>) iprobe
    Thru12 (sra_res\<19\> C\<19\>) iprobe
    Thru11 (sra_res\<20\> C\<20\>) iprobe
    Thru10 (sra_res\<21\> C\<21\>) iprobe
    Thru9 (sra_res\<22\> C\<22\>) iprobe
    Thru8 (sra_res\<23\> C\<23\>) iprobe
    Thru7 (sra_res\<24\> C\<24\>) iprobe
    Thru6 (sra_res\<25\> C\<25\>) iprobe
    Thru5 (sra_res\<26\> C\<26\>) iprobe
    Thru4 (sra_res\<27\> C\<27\>) iprobe
    Thru3 (sra_res\<28\> C\<28\>) iprobe
    Thru2 (sra_res\<29\> C\<29\>) iprobe
    Thru1 (sra_res\<30\> C\<30\>) iprobe
    Thru0 (A\<31\> C\<31\>) iprobe
ends alu_sra

// power_gating_fine/alu_srl/schematic
subckt alu_srl pwr_en A\<31\> A\<30\> A\<29\> A\<28\> A\<27\> A\<26\> A\<25\> A\<24\> A\<23\> A\<22\> A\<21\> A\<20\> A\<19\> A\<18\> A\<17\> A\<16\> A\<15\> A\<14\> A\<13\> A\<12\> A\<11\> A\<10\> A\<9\> A\<8\> A\<7\> A\<6\> A\<5\> A\<4\> A\<3\> A\<2\> A\<1\> A\<0\> B\<4\> B\<3\> B\<2\> B\<1\> B\<0\> C\<31\> C\<30\> C\<29\> C\<28\> C\<27\> C\<26\> C\<25\> C\<24\> C\<23\> C\<22\> C\<21\> C\<20\> C\<19\> C\<18\> C\<17\> C\<16\> C\<15\> C\<14\> C\<13\> C\<12\> C\<11\> C\<10\> C\<9\> C\<8\> C\<7\> C\<6\> C\<5\> C\<4\> C\<3\> C\<2\> C\<1\> C\<0\> inh_gnd inh_gnds vdd_in inh_vdds
    UG160 (pwr_en pwr_en_bar inh_gnd inh_gnds vdd_in inh_vdds) LVT_invx2_PB4_AFBB
    alu_srl_pwr_pmos (inh_vdd pwr_en_bar vdd_in inh_vdds) lvtpfet w=8000n l=30.00n nf=(2)*(1) ngcon=1 nsig_delvto_uo1=0 nsig_delvto_uo2=0 soa=1 swshe=0 swacc=0 swrg=0 swrsub=0 mismatch=1 m=1
    U144 (A\<16\> n529 inh_gnd inh_gnds inh_vdd inh_vdds) LVT_invx2_PB4_AFBB
    U141 (A\<17\> n526 inh_gnd inh_gnds inh_vdd inh_vdds) LVT_invx2_PB4_AFBB
    U32 (n208 n20 inh_gnd inh_gnds inh_vdd inh_vdds) LVT_invx2_PB4_AFBB
    U83 (A\<18\> n525 inh_gnd inh_gnds inh_vdd inh_vdds) LVT_invx2_PB4_AFBB
    U150 (A\<19\> n507 inh_gnd inh_gnds inh_vdd inh_vdds) LVT_invx2_PB4_AFBB
    U26 (n334 n333 inh_gnd inh_gnds inh_vdd inh_vdds) LVT_invx2_PB4_AFBB
    U24 (n597 n585 inh_gnd inh_gnds inh_vdd inh_vdds) LVT_invx2_PB4_AFBB
    U9 (n608 n607 inh_gnd inh_gnds inh_vdd inh_vdds) LVT_invx2_PB4_AFBB
    U230 (n127 n163 inh_gnd inh_gnds inh_vdd inh_vdds) LVT_invx2_PB4_AFBB
    U13 (n147 n6 inh_gnd inh_gnds inh_vdd inh_vdds) LVT_invx2_PB4_AFBB
    U194 (n136 n137 inh_gnd inh_gnds inh_vdd inh_vdds) LVT_invx2_PB4_AFBB
    U117 (n84 n85 inh_gnd inh_gnds inh_vdd inh_vdds) LVT_invx2_PB4_AFBB
    U21 (B\<4\> n12 inh_gnd inh_gnds inh_vdd inh_vdds) LVT_invx2_PB4_AFBB
    U186 (n622 n596 inh_gnd inh_gnds inh_vdd inh_vdds) LVT_invx2_PB4_AFBB
    U3 (n158 n2 inh_gnd inh_gnds inh_vdd inh_vdds) LVT_invx2_PB4_AFBB
    U187 (n394 n313 inh_gnd inh_gnds inh_vdd inh_vdds) LVT_invx2_PB4_AFBB
    U20 (B\<4\> n11 inh_gnd inh_gnds inh_vdd inh_vdds) LVT_invx2_PB4_AFBB
    U56 (A\<4\> n42 inh_gnd inh_gnds inh_vdd inh_vdds) LVT_invx2_PB4_AFBB
    U6 (n306 n304 inh_gnd inh_gnds inh_vdd inh_vdds) LVT_invx2_PB4_AFBB
    U180 (n84 n132 inh_gnd inh_gnds inh_vdd inh_vdds) LVT_invx2_PB4_AFBB
    U79 (A\<3\> n60 inh_gnd inh_gnds inh_vdd inh_vdds) LVT_invx2_PB4_AFBB
    U124 (A\<5\> n91 inh_gnd inh_gnds inh_vdd inh_vdds) LVT_invx2_PB4_AFBB
    U172 (n160 n124 inh_gnd inh_gnds inh_vdd inh_vdds) LVT_invx2_PB4_AFBB
    U188 (n403 n386 inh_gnd inh_gnds inh_vdd inh_vdds) LVT_invx2_PB4_AFBB
    U190 (n399 n133 inh_gnd inh_gnds inh_vdd inh_vdds) LVT_invx2_PB4_AFBB
    U231 (n205 n181 inh_gnd inh_gnds inh_vdd inh_vdds) LVT_invx2_PB4_AFBB
    U227 (n269 n160 inh_gnd inh_gnds inh_vdd inh_vdds) LVT_invx2_PB4_AFBB
    U192 (n133 n135 inh_gnd inh_gnds inh_vdd inh_vdds) LVT_invx2_PB4_AFBB
    U191 (n133 n134 inh_gnd inh_gnds inh_vdd inh_vdds) LVT_invx2_PB4_AFBB
    U226 (n158 n159 inh_gnd inh_gnds inh_vdd inh_vdds) LVT_invx2_PB4_AFBB
    U22 (B\<4\> n13 inh_gnd inh_gnds inh_vdd inh_vdds) LVT_invx2_PB4_AFBB
    U12 (n358 n357 inh_gnd inh_gnds inh_vdd inh_vdds) LVT_invx2_PB4_AFBB
    U64 (n190 n49 inh_gnd inh_gnds inh_vdd inh_vdds) LVT_invx2_PB4_AFBB
    U49 (n189 n37 inh_gnd inh_gnds inh_vdd inh_vdds) LVT_invx2_PB4_AFBB
    U61 (n180 n46 inh_gnd inh_gnds inh_vdd inh_vdds) LVT_invx2_PB4_AFBB
    U217 (n410 n179 inh_gnd inh_gnds inh_vdd inh_vdds) LVT_invx2_PB4_AFBB
    U5 (n244 n238 inh_gnd inh_gnds inh_vdd inh_vdds) LVT_invx2_PB4_AFBB
    U119 (A\<7\> n87 inh_gnd inh_gnds inh_vdd inh_vdds) LVT_invx2_PB4_AFBB
    U123 (A\<5\> n90 inh_gnd inh_gnds inh_vdd inh_vdds) LVT_invx2_PB4_AFBB
    U67 (A\<6\> n52 inh_gnd inh_gnds inh_vdd inh_vdds) LVT_invx2_PB4_AFBB
    U128 (n160 n94 inh_gnd inh_gnds inh_vdd inh_vdds) LVT_invx2_PB4_AFBB
    U164 (A\<8\> n118 inh_gnd inh_gnds inh_vdd inh_vdds) LVT_invx2_PB4_AFBB
    U11 (n432 n431 inh_gnd inh_gnds inh_vdd inh_vdds) LVT_invx2_PB4_AFBB
    U211 (n274 n151 inh_gnd inh_gnds inh_vdd inh_vdds) LVT_invx2_PB4_AFBB
    U216 (B\<1\> n651 inh_gnd inh_gnds inh_vdd inh_vdds) LVT_invx2_PB4_AFBB
    U34 (n291 n22 inh_gnd inh_gnds inh_vdd inh_vdds) LVT_invx2_PB4_AFBB
    U28 (B\<2\> n17 inh_gnd inh_gnds inh_vdd inh_vdds) LVT_invx2_PB4_AFBB
    U7 (n187 n184 inh_gnd inh_gnds inh_vdd inh_vdds) LVT_invx2_PB4_AFBB
    U38 (B\<1\> n26 inh_gnd inh_gnds inh_vdd inh_vdds) LVT_invx2_PB4_AFBB
    U193 (n368 n136 inh_gnd inh_gnds inh_vdd inh_vdds) LVT_invx2_PB4_AFBB
    U118 (n136 n86 inh_gnd inh_gnds inh_vdd inh_vdds) LVT_invx2_PB4_AFBB
    U131 (n95 n97 inh_gnd inh_gnds inh_vdd inh_vdds) LVT_invx2_PB4_AFBB
    U130 (n95 n96 inh_gnd inh_gnds inh_vdd inh_vdds) LVT_invx2_PB4_AFBB
    U129 (n371 n95 inh_gnd inh_gnds inh_vdd inh_vdds) LVT_invx2_PB4_AFBB
    U136 (n243 n186 inh_gnd inh_gnds inh_vdd inh_vdds) LVT_invx2_PB4_AFBB
    U51 (n37 n39 inh_gnd inh_gnds inh_vdd inh_vdds) LVT_invx2_PB4_AFBB
    U50 (n37 n38 inh_gnd inh_gnds inh_vdd inh_vdds) LVT_invx2_PB4_AFBB
    U65 (n49 n50 inh_gnd inh_gnds inh_vdd inh_vdds) LVT_invx2_PB4_AFBB
    U66 (n49 n51 inh_gnd inh_gnds inh_vdd inh_vdds) LVT_invx2_PB4_AFBB
    U101 (A\<20\> n506 inh_gnd inh_gnds inh_vdd inh_vdds) LVT_invx2_PB4_AFBB
    U153 (A\<21\> n503 inh_gnd inh_gnds inh_vdd inh_vdds) LVT_invx2_PB4_AFBB
    U42 (n206 n30 inh_gnd inh_gnds inh_vdd inh_vdds) LVT_invx2_PB4_AFBB
    U147 (A\<22\> n502 inh_gnd inh_gnds inh_vdd inh_vdds) LVT_invx2_PB4_AFBB
    U113 (A\<23\> n517 inh_gnd inh_gnds inh_vdd inh_vdds) LVT_invx2_PB4_AFBB
    U4 (n27 n3 inh_gnd inh_gnds inh_vdd inh_vdds) LVT_invx2_PB4_AFBB
    U232 (n144 n164 inh_gnd inh_gnds inh_vdd inh_vdds) LVT_invx2_PB4_AFBB
    U189 (n393 n316 inh_gnd inh_gnds inh_vdd inh_vdds) LVT_invx2_PB4_AFBB
    U197 (n437 n178 inh_gnd inh_gnds inh_vdd inh_vdds) LVT_invx2_PB4_AFBB
    U15 (B\<4\> n7 inh_gnd inh_gnds inh_vdd inh_vdds) LVT_invx2_PB4_AFBB
    U80 (A\<3\> n276 inh_gnd inh_gnds inh_vdd inh_vdds) LVT_invx2_PB4_AFBB
    U57 (A\<4\> n43 inh_gnd inh_gnds inh_vdd inh_vdds) LVT_invx2_PB4_AFBB
    U126 (A\<5\> n271 inh_gnd inh_gnds inh_vdd inh_vdds) LVT_invx2_PB4_AFBB
    U70 (A\<6\> n270 inh_gnd inh_gnds inh_vdd inh_vdds) LVT_invx2_PB4_AFBB
    U46 (n33 n34 inh_gnd inh_gnds inh_vdd inh_vdds) LVT_invx2_PB4_AFBB
    U163 (n531 n222 inh_gnd inh_gnds inh_vdd inh_vdds) LVT_invx2_PB4_AFBB
    U94 (A\<11\> n70 inh_gnd inh_gnds inh_vdd inh_vdds) LVT_invx2_PB4_AFBB
    U91 (A\<12\> n68 inh_gnd inh_gnds inh_vdd inh_vdds) LVT_invx2_PB4_AFBB
    U88 (A\<13\> n66 inh_gnd inh_gnds inh_vdd inh_vdds) LVT_invx2_PB4_AFBB
    U85 (A\<14\> n64 inh_gnd inh_gnds inh_vdd inh_vdds) LVT_invx2_PB4_AFBB
    U178 (B\<4\> n130 inh_gnd inh_gnds inh_vdd inh_vdds) LVT_invx2_PB4_AFBB
    U78 (n327 srl_res\<23\> inh_gnd inh_gnds inh_vdd inh_vdds) LVT_invx2_PB4_AFBB
    U122 (A\<7\> n286 inh_gnd inh_gnds inh_vdd inh_vdds) LVT_invx2_PB4_AFBB
    U155 (A\<9\> n113 inh_gnd inh_gnds inh_vdd inh_vdds) LVT_invx2_PB4_AFBB
    U167 (A\<8\> n285 inh_gnd inh_gnds inh_vdd inh_vdds) LVT_invx2_PB4_AFBB
    U97 (A\<10\> n72 inh_gnd inh_gnds inh_vdd inh_vdds) LVT_invx2_PB4_AFBB
    U140 (A\<17\> n103 inh_gnd inh_gnds inh_vdd inh_vdds) LVT_invx2_PB4_AFBB
    U103 (A\<15\> n76 inh_gnd inh_gnds inh_vdd inh_vdds) LVT_invx2_PB4_AFBB
    U143 (A\<16\> n105 inh_gnd inh_gnds inh_vdd inh_vdds) LVT_invx2_PB4_AFBB
    U82 (A\<18\> n62 inh_gnd inh_gnds inh_vdd inh_vdds) LVT_invx2_PB4_AFBB
    U138 (n318 n317 inh_gnd inh_gnds inh_vdd inh_vdds) LVT_invx2_PB4_AFBB
    U184 (n520 n221 inh_gnd inh_gnds inh_vdd inh_vdds) LVT_invx2_PB4_AFBB
    U205 (n144 n146 inh_gnd inh_gnds inh_vdd inh_vdds) LVT_invx2_PB4_AFBB
    U31 (n520 n19 inh_gnd inh_gnds inh_vdd inh_vdds) LVT_invx2_PB4_AFBB
    U115 (n331 n389 inh_gnd inh_gnds inh_vdd inh_vdds) LVT_invx2_PB4_AFBB
    U210 (B\<4\> n288 inh_gnd inh_gnds inh_vdd inh_vdds) LVT_invx2_PB4_AFBB
    U14 (n345 srl_res\<21\> inh_gnd inh_gnds inh_vdd inh_vdds) LVT_invx2_PB4_AFBB
    U200 (n140 n142 inh_gnd inh_gnds inh_vdd inh_vdds) LVT_invx2_PB4_AFBB
    U43 (n30 n31 inh_gnd inh_gnds inh_vdd inh_vdds) LVT_invx2_PB4_AFBB
    U218 (n29 n355 inh_gnd inh_gnds inh_vdd inh_vdds) LVT_invx2_PB4_AFBB
    U223 (n156 n157 inh_gnd inh_gnds inh_vdd inh_vdds) LVT_invx2_PB4_AFBB
    U201 (n140 n143 inh_gnd inh_gnds inh_vdd inh_vdds) LVT_invx2_PB4_AFBB
    U221 (n36 n292 inh_gnd inh_gnds inh_vdd inh_vdds) LVT_invx2_PB4_AFBB
    U16 (B\<4\> n8 inh_gnd inh_gnds inh_vdd inh_vdds) LVT_invx2_PB4_AFBB
    U203 (n188 n144 inh_gnd inh_gnds inh_vdd inh_vdds) LVT_invx2_PB4_AFBB
    U60 (n44 n45 inh_gnd inh_gnds inh_vdd inh_vdds) LVT_invx2_PB4_AFBB
    U233 (n164 n165 inh_gnd inh_gnds inh_vdd inh_vdds) LVT_invx2_PB4_AFBB
    U59 (n198 n44 inh_gnd inh_gnds inh_vdd inh_vdds) LVT_invx2_PB4_AFBB
    U159 (A\<28\> n496 inh_gnd inh_gnds inh_vdd inh_vdds) LVT_invx2_PB4_AFBB
    U170 (A\<29\> n123 inh_gnd inh_gnds inh_vdd inh_vdds) LVT_invx2_PB4_AFBB
    U174 (n56 n126 inh_gnd inh_gnds inh_vdd inh_vdds) LVT_invx2_PB4_AFBB
    U18 (A\<30\> n493 inh_gnd inh_gnds inh_vdd inh_vdds) LVT_invx2_PB4_AFBB
    U29 (A\<31\> n18 inh_gnd inh_gnds inh_vdd inh_vdds) LVT_invx2_PB4_AFBB
    U209 (n147 n150 inh_gnd inh_gnds inh_vdd inh_vdds) LVT_invx2_PB4_AFBB
    U58 (A\<4\> n275 inh_gnd inh_gnds inh_vdd inh_vdds) LVT_invx2_PB4_AFBB
    U125 (A\<5\> n92 inh_gnd inh_gnds inh_vdd inh_vdds) LVT_invx2_PB4_AFBB
    U69 (A\<6\> n54 inh_gnd inh_gnds inh_vdd inh_vdds) LVT_invx2_PB4_AFBB
    U121 (A\<7\> n89 inh_gnd inh_gnds inh_vdd inh_vdds) LVT_invx2_PB4_AFBB
    U33 (n20 n21 inh_gnd inh_gnds inh_vdd inh_vdds) LVT_invx2_PB4_AFBB
    U220 (n589 n209 inh_gnd inh_gnds inh_vdd inh_vdds) LVT_invx2_PB4_AFBB
    U98 (A\<10\> n281 inh_gnd inh_gnds inh_vdd inh_vdds) LVT_invx2_PB4_AFBB
    U166 (A\<8\> n120 inh_gnd inh_gnds inh_vdd inh_vdds) LVT_invx2_PB4_AFBB
    U156 (A\<9\> n282 inh_gnd inh_gnds inh_vdd inh_vdds) LVT_invx2_PB4_AFBB
    U95 (A\<11\> n541 inh_gnd inh_gnds inh_vdd inh_vdds) LVT_invx2_PB4_AFBB
    U183 (n476 n200 inh_gnd inh_gnds inh_vdd inh_vdds) LVT_invx2_PB4_AFBB
    U92 (A\<12\> n540 inh_gnd inh_gnds inh_vdd inh_vdds) LVT_invx2_PB4_AFBB
    U89 (A\<13\> n537 inh_gnd inh_gnds inh_vdd inh_vdds) LVT_invx2_PB4_AFBB
    U86 (A\<14\> n536 inh_gnd inh_gnds inh_vdd inh_vdds) LVT_invx2_PB4_AFBB
    U102 (A\<15\> n75 inh_gnd inh_gnds inh_vdd inh_vdds) LVT_invx2_PB4_AFBB
    U198 (n337 n140 inh_gnd inh_gnds inh_vdd inh_vdds) LVT_invx2_PB4_AFBB
    U27 (B\<2\> n16 inh_gnd inh_gnds inh_vdd inh_vdds) LVT_invx2_PB4_AFBB
    U77 (n350 srl_res\<20\> inh_gnd inh_gnds inh_vdd inh_vdds) LVT_invx2_PB4_AFBB
    U179 (B\<4\> n131 inh_gnd inh_gnds inh_vdd inh_vdds) LVT_invx2_PB4_AFBB
    U202 (B\<2\> n488 inh_gnd inh_gnds inh_vdd inh_vdds) LVT_invx2_PB4_AFBB
    U224 (n59 n344 inh_gnd inh_gnds inh_vdd inh_vdds) LVT_invx2_PB4_AFBB
    U23 (B\<4\> n14 inh_gnd inh_gnds inh_vdd inh_vdds) LVT_invx2_PB4_AFBB
    U238 (n207 n191 inh_gnd inh_gnds inh_vdd inh_vdds) LVT_invx2_PB4_AFBB
    U127 (n336 n93 inh_gnd inh_gnds inh_vdd inh_vdds) LVT_invx2_PB4_AFBB
    U225 (n93 n158 inh_gnd inh_gnds inh_vdd inh_vdds) LVT_invx2_PB4_AFBB
    U222 (n344 n156 inh_gnd inh_gnds inh_vdd inh_vdds) LVT_invx2_PB4_AFBB
    U199 (n140 n141 inh_gnd inh_gnds inh_vdd inh_vdds) LVT_invx2_PB4_AFBB
    U134 (n99 n100 inh_gnd inh_gnds inh_vdd inh_vdds) LVT_invx2_PB4_AFBB
    U8 (n166 n4 inh_gnd inh_gnds inh_vdd inh_vdds) LVT_invx2_PB4_AFBB
    U55 (A\<24\> n516 inh_gnd inh_gnds inh_vdd inh_vdds) LVT_invx2_PB4_AFBB
    U108 (A\<25\> n79 inh_gnd inh_gnds inh_vdd inh_vdds) LVT_invx2_PB4_AFBB
    U160 (A\<26\> n116 inh_gnd inh_gnds inh_vdd inh_vdds) LVT_invx2_PB4_AFBB
    U107 (A\<27\> n497 inh_gnd inh_gnds inh_vdd inh_vdds) LVT_invx2_PB4_AFBB
    U208 (n147 n149 inh_gnd inh_gnds inh_vdd inh_vdds) LVT_invx2_PB4_AFBB
    U47 (n321 n35 inh_gnd inh_gnds inh_vdd inh_vdds) LVT_invx2_PB4_AFBB
    U41 (n28 n29 inh_gnd inh_gnds inh_vdd inh_vdds) LVT_invx2_PB4_AFBB
    U40 (n199 n28 inh_gnd inh_gnds inh_vdd inh_vdds) LVT_invx2_PB4_AFBB
    U48 (n35 n36 inh_gnd inh_gnds inh_vdd inh_vdds) LVT_invx2_PB4_AFBB
    U76 (n25 n402 inh_gnd inh_gnds inh_vdd inh_vdds) LVT_invx2_PB4_AFBB
    U37 (n24 n25 inh_gnd inh_gnds inh_vdd inh_vdds) LVT_invx2_PB4_AFBB
    U36 (n322 n24 inh_gnd inh_gnds inh_vdd inh_vdds) LVT_invx2_PB4_AFBB
    U161 (A\<26\> n117 inh_gnd inh_gnds inh_vdd inh_vdds) LVT_invx2_PB4_AFBB
    U105 (A\<27\> n77 inh_gnd inh_gnds inh_vdd inh_vdds) LVT_invx2_PB4_AFBB
    U157 (A\<28\> n114 inh_gnd inh_gnds inh_vdd inh_vdds) LVT_invx2_PB4_AFBB
    U168 (A\<29\> n121 inh_gnd inh_gnds inh_vdd inh_vdds) LVT_invx2_PB4_AFBB
    U90 (A\<12\> n67 inh_gnd inh_gnds inh_vdd inh_vdds) LVT_invx2_PB4_AFBB
    U87 (A\<13\> n65 inh_gnd inh_gnds inh_vdd inh_vdds) LVT_invx2_PB4_AFBB
    U137 (n578 n234 inh_gnd inh_gnds inh_vdd inh_vdds) LVT_invx2_PB4_AFBB
    U96 (A\<10\> n71 inh_gnd inh_gnds inh_vdd inh_vdds) LVT_invx2_PB4_AFBB
    U93 (A\<11\> n69 inh_gnd inh_gnds inh_vdd inh_vdds) LVT_invx2_PB4_AFBB
    U71 (n151 n55 inh_gnd inh_gnds inh_vdd inh_vdds) LVT_invx2_PB4_AFBB
    U181 (n426 n343 inh_gnd inh_gnds inh_vdd inh_vdds) LVT_invx2_PB4_AFBB
    U236 (n166 n168 inh_gnd inh_gnds inh_vdd inh_vdds) LVT_invx2_PB4_AFBB
    U145 (A\<22\> n106 inh_gnd inh_gnds inh_vdd inh_vdds) LVT_invx2_PB4_AFBB
    U111 (A\<23\> n81 inh_gnd inh_gnds inh_vdd inh_vdds) LVT_invx2_PB4_AFBB
    U53 (A\<24\> n40 inh_gnd inh_gnds inh_vdd inh_vdds) LVT_invx2_PB4_AFBB
    U110 (A\<25\> n513 inh_gnd inh_gnds inh_vdd inh_vdds) LVT_invx2_PB4_AFBB
    U45 (n392 n33 inh_gnd inh_gnds inh_vdd inh_vdds) LVT_invx2_PB4_AFBB
    U149 (A\<19\> n109 inh_gnd inh_gnds inh_vdd inh_vdds) LVT_invx2_PB4_AFBB
    U235 (n27 n167 inh_gnd inh_gnds inh_vdd inh_vdds) LVT_invx2_PB4_AFBB
    U39 (n191 n27 inh_gnd inh_gnds inh_vdd inh_vdds) LVT_invx2_PB4_AFBB
    U204 (n144 n145 inh_gnd inh_gnds inh_vdd inh_vdds) LVT_invx2_PB4_AFBB
    U195 (n178 n138 inh_gnd inh_gnds inh_vdd inh_vdds) LVT_invx2_PB4_AFBB
    U212 (n57 n152 inh_gnd inh_gnds inh_vdd inh_vdds) LVT_invx2_PB4_AFBB
    U206 (n210 n147 inh_gnd inh_gnds inh_vdd inh_vdds) LVT_invx2_PB4_AFBB
    U176 (B\<4\> n128 inh_gnd inh_gnds inh_vdd inh_vdds) LVT_invx2_PB4_AFBB
    U207 (n147 n148 inh_gnd inh_gnds inh_vdd inh_vdds) LVT_invx2_PB4_AFBB
    U35 (n22 n23 inh_gnd inh_gnds inh_vdd inh_vdds) LVT_invx2_PB4_AFBB
    U196 (n138 n139 inh_gnd inh_gnds inh_vdd inh_vdds) LVT_invx2_PB4_AFBB
    U44 (n177 n32 inh_gnd inh_gnds inh_vdd inh_vdds) LVT_invx2_PB4_AFBB
    U132 (n10 n98 inh_gnd inh_gnds inh_vdd inh_vdds) LVT_invx2_PB4_AFBB
    U237 (n166 n169 inh_gnd inh_gnds inh_vdd inh_vdds) LVT_invx2_PB4_AFBB
    U234 (n191 n166 inh_gnd inh_gnds inh_vdd inh_vdds) LVT_invx2_PB4_AFBB
    U63 (n46 n48 inh_gnd inh_gnds inh_vdd inh_vdds) LVT_invx2_PB4_AFBB
    U62 (n46 n47 inh_gnd inh_gnds inh_vdd inh_vdds) LVT_invx2_PB4_AFBB
    U229 (n127 n162 inh_gnd inh_gnds inh_vdd inh_vdds) LVT_invx2_PB4_AFBB
    U175 (n181 n127 inh_gnd inh_gnds inh_vdd inh_vdds) LVT_invx2_PB4_AFBB
    U30 (A\<31\> n443 inh_gnd inh_gnds inh_vdd inh_vdds) LVT_invx2_PB4_AFBB
    U171 (A\<29\> n442 inh_gnd inh_gnds inh_vdd inh_vdds) LVT_invx2_PB4_AFBB
    U114 (n181 n83 inh_gnd inh_gnds inh_vdd inh_vdds) LVT_invx2_PB4_AFBB
    U106 (A\<27\> n78 inh_gnd inh_gnds inh_vdd inh_vdds) LVT_invx2_PB4_AFBB
    U158 (A\<28\> n115 inh_gnd inh_gnds inh_vdd inh_vdds) LVT_invx2_PB4_AFBB
    U213 (n57 n153 inh_gnd inh_gnds inh_vdd inh_vdds) LVT_invx2_PB4_AFBB
    U169 (A\<29\> n122 inh_gnd inh_gnds inh_vdd inh_vdds) LVT_invx2_PB4_AFBB
    U17 (A\<30\> n9 inh_gnd inh_gnds inh_vdd inh_vdds) LVT_invx2_PB4_AFBB
    U185 (n429 n235 inh_gnd inh_gnds inh_vdd inh_vdds) LVT_invx2_PB4_AFBB
    U142 (A\<16\> n104 inh_gnd inh_gnds inh_vdd inh_vdds) LVT_invx2_PB4_AFBB
    U84 (A\<14\> n63 inh_gnd inh_gnds inh_vdd inh_vdds) LVT_invx2_PB4_AFBB
    U104 (A\<15\> n530 inh_gnd inh_gnds inh_vdd inh_vdds) LVT_invx2_PB4_AFBB
    U139 (A\<17\> n102 inh_gnd inh_gnds inh_vdd inh_vdds) LVT_invx2_PB4_AFBB
    U162 (A\<26\> n512 inh_gnd inh_gnds inh_vdd inh_vdds) LVT_invx2_PB4_AFBB
    U109 (A\<25\> n80 inh_gnd inh_gnds inh_vdd inh_vdds) LVT_invx2_PB4_AFBB
    U112 (A\<23\> n82 inh_gnd inh_gnds inh_vdd inh_vdds) LVT_invx2_PB4_AFBB
    U54 (A\<24\> n41 inh_gnd inh_gnds inh_vdd inh_vdds) LVT_invx2_PB4_AFBB
    U52 (n338 srl_res\<22\> inh_gnd inh_gnds inh_vdd inh_vdds) LVT_invx2_PB4_AFBB
    U177 (B\<4\> n129 inh_gnd inh_gnds inh_vdd inh_vdds) LVT_invx2_PB4_AFBB
    U228 (n181 n161 inh_gnd inh_gnds inh_vdd inh_vdds) LVT_invx2_PB4_AFBB
    U2 (n161 n1 inh_gnd inh_gnds inh_vdd inh_vdds) LVT_invx2_PB4_AFBB
    U182 (n425 n231 inh_gnd inh_gnds inh_vdd inh_vdds) LVT_invx2_PB4_AFBB
    U133 (n147 n99 inh_gnd inh_gnds inh_vdd inh_vdds) LVT_invx2_PB4_AFBB
    U135 (n99 n101 inh_gnd inh_gnds inh_vdd inh_vdds) LVT_invx2_PB4_AFBB
    U68 (A\<6\> n53 inh_gnd inh_gnds inh_vdd inh_vdds) LVT_invx2_PB4_AFBB
    U81 (A\<18\> n61 inh_gnd inh_gnds inh_vdd inh_vdds) LVT_invx2_PB4_AFBB
    U148 (A\<19\> n108 inh_gnd inh_gnds inh_vdd inh_vdds) LVT_invx2_PB4_AFBB
    U99 (A\<20\> n73 inh_gnd inh_gnds inh_vdd inh_vdds) LVT_invx2_PB4_AFBB
    U151 (A\<21\> n110 inh_gnd inh_gnds inh_vdd inh_vdds) LVT_invx2_PB4_AFBB
    U120 (A\<7\> n88 inh_gnd inh_gnds inh_vdd inh_vdds) LVT_invx2_PB4_AFBB
    U214 (n56 n154 inh_gnd inh_gnds inh_vdd inh_vdds) LVT_invx2_PB4_AFBB
    U72 (n15 n56 inh_gnd inh_gnds inh_vdd inh_vdds) LVT_invx2_PB4_AFBB
    U165 (A\<8\> n119 inh_gnd inh_gnds inh_vdd inh_vdds) LVT_invx2_PB4_AFBB
    U154 (A\<9\> n112 inh_gnd inh_gnds inh_vdd inh_vdds) LVT_invx2_PB4_AFBB
    U152 (A\<21\> n111 inh_gnd inh_gnds inh_vdd inh_vdds) LVT_invx2_PB4_AFBB
    U146 (A\<22\> n107 inh_gnd inh_gnds inh_vdd inh_vdds) LVT_invx2_PB4_AFBB
    U116 (n5 n84 inh_gnd inh_gnds inh_vdd inh_vdds) LVT_invx2_PB4_AFBB
    U25 (n371 n15 inh_gnd inh_gnds inh_vdd inh_vdds) LVT_invx2_PB4_AFBB
    U219 (n155 n371 inh_gnd inh_gnds inh_vdd inh_vdds) LVT_invx2_PB4_AFBB
    U215 (n151 n155 inh_gnd inh_gnds inh_vdd inh_vdds) LVT_invx2_PB4_AFBB
    U19 (n151 n10 inh_gnd inh_gnds inh_vdd inh_vdds) LVT_invx2_PB4_AFBB
    U100 (A\<20\> n74 inh_gnd inh_gnds inh_vdd inh_vdds) LVT_invx2_PB4_AFBB
    U73 (n10 n57 inh_gnd inh_gnds inh_vdd inh_vdds) LVT_invx2_PB4_AFBB
    U173 (n57 n125 inh_gnd inh_gnds inh_vdd inh_vdds) LVT_invx2_PB4_AFBB
    U686 (n84 n529 n652 inh_gnd inh_gnds inh_vdd inh_vdds) LVT_NOR2x1_PB4_AFBB
    U684 (n154 n526 n653 inh_gnd inh_gnds inh_vdd inh_vdds) LVT_NOR2x1_PB4_AFBB
    U683 (n652 n653 n647 inh_gnd inh_gnds inh_vdd inh_vdds) LVT_NOR2x1_PB4_AFBB
    U681 (n136 n525 n649 inh_gnd inh_gnds inh_vdd inh_vdds) LVT_NOR2x1_PB4_AFBB
    U679 (n269 n507 n650 inh_gnd inh_gnds inh_vdd inh_vdds) LVT_NOR2x1_PB4_AFBB
    U678 (n650 n649 n648 inh_gnd inh_gnds inh_vdd inh_vdds) LVT_NOR2x1_PB4_AFBB
    U676 (B\<2\> B\<3\> n330 inh_gnd inh_gnds inh_vdd inh_vdds) LVT_NOR2x1_PB4_AFBB
    U363 (n143 n23 n332 inh_gnd inh_gnds inh_vdd inh_vdds) LVT_NOR2x1_PB4_AFBB
    U361 (n332 n333 n328 inh_gnd inh_gnds inh_vdd inh_vdds) LVT_NOR2x1_PB4_AFBB
    U625 (n606 n607 n598 inh_gnd inh_gnds inh_vdd inh_vdds) LVT_NOR2x1_PB4_AFBB
    U637 (n616 n617 n615 inh_gnd inh_gnds inh_vdd inh_vdds) LVT_NOR2x1_PB4_AFBB
    U635 (n615 n6 n606 inh_gnd inh_gnds inh_vdd inh_vdds) LVT_NOR2x1_PB4_AFBB
    U614 (n596 n12 n587 inh_gnd inh_gnds inh_vdd inh_vdds) LVT_NOR2x1_PB4_AFBB
    U605 (n209 n3 n588 inh_gnd inh_gnds inh_vdd inh_vdds) LVT_NOR2x1_PB4_AFBB
    U604 (n587 n588 n586 inh_gnd inh_gnds inh_vdd inh_vdds) LVT_NOR2x1_PB4_AFBB
    U665 (n639 n640 n623 inh_gnd inh_gnds inh_vdd inh_vdds) LVT_NOR2x1_PB4_AFBB
    U666 (n30 n2 n640 inh_gnd inh_gnds inh_vdd inh_vdds) LVT_NOR2x1_PB4_AFBB
    U432 (n51 n157 n409 inh_gnd inh_gnds inh_vdd inh_vdds) LVT_NOR2x1_PB4_AFBB
    U675 (n157 n20 n639 inh_gnd inh_gnds inh_vdd inh_vdds) LVT_NOR2x1_PB4_AFBB
    U647 (n143 n355 n626 inh_gnd inh_gnds inh_vdd inh_vdds) LVT_NOR2x1_PB4_AFBB
    U656 (n44 n135 n625 inh_gnd inh_gnds inh_vdd inh_vdds) LVT_NOR2x1_PB4_AFBB
    U646 (n625 n626 n624 inh_gnd inh_gnds inh_vdd inh_vdds) LVT_NOR2x1_PB4_AFBB
    U422 (n292 n135 n397 inh_gnd inh_gnds inh_vdd inh_vdds) LVT_NOR2x1_PB4_AFBB
    U421 (n231 n344 n398 inh_gnd inh_gnds inh_vdd inh_vdds) LVT_NOR2x1_PB4_AFBB
    U420 (n397 n398 n396 inh_gnd inh_gnds inh_vdd inh_vdds) LVT_NOR2x1_PB4_AFBB
    U424 (n143 n402 n401 inh_gnd inh_gnds inh_vdd inh_vdds) LVT_NOR2x1_PB4_AFBB
    U425 (n159 n343 n400 inh_gnd inh_gnds inh_vdd inh_vdds) LVT_NOR2x1_PB4_AFBB
    U423 (n401 n400 n395 inh_gnd inh_gnds inh_vdd inh_vdds) LVT_NOR2x1_PB4_AFBB
    U341 (n313 n11 n295 inh_gnd inh_gnds inh_vdd inh_vdds) LVT_NOR2x1_PB4_AFBB
    U342 (n314 n315 n293 inh_gnd inh_gnds inh_vdd inh_vdds) LVT_NOR2x1_PB4_AFBB
    U343 (n169 n234 n315 inh_gnd inh_gnds inh_vdd inh_vdds) LVT_NOR2x1_PB4_AFBB
    U323 (n296 n295 n294 inh_gnd inh_gnds inh_vdd inh_vdds) LVT_NOR2x1_PB4_AFBB
    U344 (n163 n235 n314 inh_gnd inh_gnds inh_vdd inh_vdds) LVT_NOR2x1_PB4_AFBB
    U327 (n302 n303 n301 inh_gnd inh_gnds inh_vdd inh_vdds) LVT_NOR2x1_PB4_AFBB
    U329 (n136 n42 n302 inh_gnd inh_gnds inh_vdd inh_vdds) LVT_NOR2x1_PB4_AFBB
    U331 (n126 n60 n305 inh_gnd inh_gnds inh_vdd inh_vdds) LVT_NOR2x1_PB4_AFBB
    U330 (n304 n305 n300 inh_gnd inh_gnds inh_vdd inh_vdds) LVT_NOR2x1_PB4_AFBB
    U328 (n124 n91 n303 inh_gnd inh_gnds inh_vdd inh_vdds) LVT_NOR2x1_PB4_AFBB
    U430 (n32 n134 n406 inh_gnd inh_gnds inh_vdd inh_vdds) LVT_NOR2x1_PB4_AFBB
    U429 (n47 n159 n407 inh_gnd inh_gnds inh_vdd inh_vdds) LVT_NOR2x1_PB4_AFBB
    U428 (n407 n406 n405 inh_gnd inh_gnds inh_vdd inh_vdds) LVT_NOR2x1_PB4_AFBB
    U433 (n410 n142 n408 inh_gnd inh_gnds inh_vdd inh_vdds) LVT_NOR2x1_PB4_AFBB
    U431 (n409 n408 n404 inh_gnd inh_gnds inh_vdd inh_vdds) LVT_NOR2x1_PB4_AFBB
    U624 (n134 B\<4\> n205 inh_gnd inh_gnds inh_vdd inh_vdds) LVT_NOR2x1_PB4_AFBB
    U644 (B\<4\> n596 C\<16\> inh_gnd inh_gnds inh_vdd inh_vdds) LVT_NOR2x1_PB4_AFBB
    U418 (B\<4\> n313 srl_res\<18\> inh_gnd inh_gnds inh_vdd inh_vdds) LVT_NOR2x1_PB4_AFBB
    U426 (B\<4\> n386 srl_res\<17\> inh_gnd inh_gnds inh_vdd inh_vdds) LVT_NOR2x1_PB4_AFBB
    U411 (n386 n13 n384 inh_gnd inh_gnds inh_vdd inh_vdds) LVT_NOR2x1_PB4_AFBB
    U410 (n162 n39 n385 inh_gnd inh_gnds inh_vdd inh_vdds) LVT_NOR2x1_PB4_AFBB
    U409 (n384 n385 n356 inh_gnd inh_gnds inh_vdd inh_vdds) LVT_NOR2x1_PB4_AFBB
    U393 (n243 n168 n361 inh_gnd inh_gnds inh_vdd inh_vdds) LVT_NOR2x1_PB4_AFBB
    U385 (n363 n148 n362 inh_gnd inh_gnds inh_vdd inh_vdds) LVT_NOR2x1_PB4_AFBB
    U386 (n364 n365 n363 inh_gnd inh_gnds inh_vdd inh_vdds) LVT_NOR2x1_PB4_AFBB
    U384 (n361 n362 n360 inh_gnd inh_gnds inh_vdd inh_vdds) LVT_NOR2x1_PB4_AFBB
    U479 (n458 n459 n190 inh_gnd inh_gnds inh_vdd inh_vdds) LVT_NOR2x1_PB4_AFBB
    U487 (n464 n465 n189 inh_gnd inh_gnds inh_vdd inh_vdds) LVT_NOR2x1_PB4_AFBB
    U462 (n444 n445 n180 inh_gnd inh_gnds inh_vdd inh_vdds) LVT_NOR2x1_PB4_AFBB
    U470 (n450 n451 n410 inh_gnd inh_gnds inh_vdd inh_vdds) LVT_NOR2x1_PB4_AFBB
    U394 (n372 n373 n243 inh_gnd inh_gnds inh_vdd inh_vdds) LVT_NOR2x1_PB4_AFBB
    U280 (n238 n239 n237 inh_gnd inh_gnds inh_vdd inh_vdds) LVT_NOR2x1_PB4_AFBB
    U403 (n381 n380 n379 inh_gnd inh_gnds inh_vdd inh_vdds) LVT_NOR2x1_PB4_AFBB
    U405 (n136 n87 n380 inh_gnd inh_gnds inh_vdd inh_vdds) LVT_NOR2x1_PB4_AFBB
    U408 (n84 n90 n382 inh_gnd inh_gnds inh_vdd inh_vdds) LVT_NOR2x1_PB4_AFBB
    U407 (n126 n52 n383 inh_gnd inh_gnds inh_vdd inh_vdds) LVT_NOR2x1_PB4_AFBB
    U406 (n382 n383 n378 inh_gnd inh_gnds inh_vdd inh_vdds) LVT_NOR2x1_PB4_AFBB
    U404 (n94 n118 n381 inh_gnd inh_gnds inh_vdd inh_vdds) LVT_NOR2x1_PB4_AFBB
    U287 (n4 n38 n246 inh_gnd inh_gnds inh_vdd inh_vdds) LVT_NOR2x1_PB4_AFBB
    U286 (n163 n50 n247 inh_gnd inh_gnds inh_vdd inh_vdds) LVT_NOR2x1_PB4_AFBB
    U285 (n246 n247 n236 inh_gnd inh_gnds inh_vdd inh_vdds) LVT_NOR2x1_PB4_AFBB
    U486 (n150 n38 n456 inh_gnd inh_gnds inh_vdd inh_vdds) LVT_NOR2x1_PB4_AFBB
    U478 (n50 n145 n457 inh_gnd inh_gnds inh_vdd inh_vdds) LVT_NOR2x1_PB4_AFBB
    U477 (n456 n457 n430 inh_gnd inh_gnds inh_vdd inh_vdds) LVT_NOR2x1_PB4_AFBB
    U248 (n164 n39 n187 inh_gnd inh_gnds inh_vdd inh_vdds) LVT_NOR2x1_PB4_AFBB
    U682 (n26 B\<0\> n368 inh_gnd inh_gnds inh_vdd inh_vdds) LVT_NOR2x1_PB4_AFBB
    U674 (n84 n506 n645 inh_gnd inh_gnds inh_vdd inh_vdds) LVT_NOR2x1_PB4_AFBB
    U673 (n153 n503 n646 inh_gnd inh_gnds inh_vdd inh_vdds) LVT_NOR2x1_PB4_AFBB
    U672 (n645 n646 n641 inh_gnd inh_gnds inh_vdd inh_vdds) LVT_NOR2x1_PB4_AFBB
    U671 (n136 n502 n643 inh_gnd inh_gnds inh_vdd inh_vdds) LVT_NOR2x1_PB4_AFBB
    U670 (n269 n517 n644 inh_gnd inh_gnds inh_vdd inh_vdds) LVT_NOR2x1_PB4_AFBB
    U669 (n643 n644 n642 inh_gnd inh_gnds inh_vdd inh_vdds) LVT_NOR2x1_PB4_AFBB
    U507 (B\<3\> n316 n485 inh_gnd inh_gnds inh_vdd inh_vdds) LVT_NOR2x1_PB4_AFBB
    U527 (n162 n389 n481 inh_gnd inh_gnds inh_vdd inh_vdds) LVT_NOR2x1_PB4_AFBB
    U504 (n482 n481 n480 inh_gnd inh_gnds inh_vdd inh_vdds) LVT_NOR2x1_PB4_AFBB
    U544 (n222 n149 n518 inh_gnd inh_gnds inh_vdd inh_vdds) LVT_NOR2x1_PB4_AFBB
    U345 (n32 n149 srl_res\<29\> inh_gnd inh_gnds inh_vdd inh_vdds) LVT_NOR2x1_PB4_AFBB
    U536 (n164 n19 n519 inh_gnd inh_gnds inh_vdd inh_vdds) LVT_NOR2x1_PB4_AFBB
    U535 (n518 n519 n479 inh_gnd inh_gnds inh_vdd inh_vdds) LVT_NOR2x1_PB4_AFBB
    U413 (n387 n388 n287 inh_gnd inh_gnds inh_vdd inh_vdds) LVT_NOR2x1_PB4_AFBB
    U414 (n389 n159 n388 inh_gnd inh_gnds inh_vdd inh_vdds) LVT_NOR2x1_PB4_AFBB
    U316 (n287 n7 n260 inh_gnd inh_gnds inh_vdd inh_vdds) LVT_NOR2x1_PB4_AFBB
    U317 (n290 n289 n258 inh_gnd inh_gnds inh_vdd inh_vdds) LVT_NOR2x1_PB4_AFBB
    U318 (n221 n1 n290 inh_gnd inh_gnds inh_vdd inh_vdds) LVT_NOR2x1_PB4_AFBB
    U298 (n261 n260 n259 inh_gnd inh_gnds inh_vdd inh_vdds) LVT_NOR2x1_PB4_AFBB
    U319 (n222 n3 n289 inh_gnd inh_gnds inh_vdd inh_vdds) LVT_NOR2x1_PB4_AFBB
    U307 (n84 n276 n272 inh_gnd inh_gnds inh_vdd inh_vdds) LVT_NOR2x1_PB4_AFBB
    U306 (n125 n43 n273 inh_gnd inh_gnds inh_vdd inh_vdds) LVT_NOR2x1_PB4_AFBB
    U305 (n272 n273 n265 inh_gnd inh_gnds inh_vdd inh_vdds) LVT_NOR2x1_PB4_AFBB
    U304 (n136 n271 n267 inh_gnd inh_gnds inh_vdd inh_vdds) LVT_NOR2x1_PB4_AFBB
    U303 (n94 n270 n268 inh_gnd inh_gnds inh_vdd inh_vdds) LVT_NOR2x1_PB4_AFBB
    U302 (n268 n267 n266 inh_gnd inh_gnds inh_vdd inh_vdds) LVT_NOR2x1_PB4_AFBB
    U266 (n163 n33 n213 inh_gnd inh_gnds inh_vdd inh_vdds) LVT_NOR2x1_PB4_AFBB
    U262 (n214 n213 n212 inh_gnd inh_gnds inh_vdd inh_vdds) LVT_NOR2x1_PB4_AFBB
    U269 (n222 n146 n219 inh_gnd inh_gnds inh_vdd inh_vdds) LVT_NOR2x1_PB4_AFBB
    U268 (n168 n221 n220 inh_gnd inh_gnds inh_vdd inh_vdds) LVT_NOR2x1_PB4_AFBB
    U267 (n219 n220 n211 inh_gnd inh_gnds inh_vdd inh_vdds) LVT_NOR2x1_PB4_AFBB
    U551 (n84 n70 n538 inh_gnd inh_gnds inh_vdd inh_vdds) LVT_NOR2x1_PB4_AFBB
    U550 (n55 n68 n539 inh_gnd inh_gnds inh_vdd inh_vdds) LVT_NOR2x1_PB4_AFBB
    U549 (n538 n539 n532 inh_gnd inh_gnds inh_vdd inh_vdds) LVT_NOR2x1_PB4_AFBB
    U548 (n136 n66 n534 inh_gnd inh_gnds inh_vdd inh_vdds) LVT_NOR2x1_PB4_AFBB
    U547 (n124 n64 n535 inh_gnd inh_gnds inh_vdd inh_vdds) LVT_NOR2x1_PB4_AFBB
    U546 (n535 n534 n533 inh_gnd inh_gnds inh_vdd inh_vdds) LVT_NOR2x1_PB4_AFBB
    U313 (n283 n284 n277 inh_gnd inh_gnds inh_vdd inh_vdds) LVT_NOR2x1_PB4_AFBB
    U315 (n84 n286 n283 inh_gnd inh_gnds inh_vdd inh_vdds) LVT_NOR2x1_PB4_AFBB
    U310 (n280 n279 n278 inh_gnd inh_gnds inh_vdd inh_vdds) LVT_NOR2x1_PB4_AFBB
    U312 (n136 n113 n279 inh_gnd inh_gnds inh_vdd inh_vdds) LVT_NOR2x1_PB4_AFBB
    U314 (n153 n285 n284 inh_gnd inh_gnds inh_vdd inh_vdds) LVT_NOR2x1_PB4_AFBB
    U311 (n269 n72 n280 inh_gnd inh_gnds inh_vdd inh_vdds) LVT_NOR2x1_PB4_AFBB
    U538 (n523 n524 n522 inh_gnd inh_gnds inh_vdd inh_vdds) LVT_NOR2x1_PB4_AFBB
    U540 (n136 n103 n523 inh_gnd inh_gnds inh_vdd inh_vdds) LVT_NOR2x1_PB4_AFBB
    U543 (n84 n76 n527 inh_gnd inh_gnds inh_vdd inh_vdds) LVT_NOR2x1_PB4_AFBB
    U542 (n152 n105 n528 inh_gnd inh_gnds inh_vdd inh_vdds) LVT_NOR2x1_PB4_AFBB
    U541 (n527 n528 n521 inh_gnd inh_gnds inh_vdd inh_vdds) LVT_NOR2x1_PB4_AFBB
    U539 (n124 n62 n524 inh_gnd inh_gnds inh_vdd inh_vdds) LVT_NOR2x1_PB4_AFBB
    U260 (n209 n6 n201 inh_gnd inh_gnds inh_vdd inh_vdds) LVT_NOR2x1_PB4_AFBB
    U441 (n6 n19 n418 inh_gnd inh_gnds inh_vdd inh_vdds) LVT_NOR2x1_PB4_AFBB
    U442 (n389 n169 n417 inh_gnd inh_gnds inh_vdd inh_vdds) LVT_NOR2x1_PB4_AFBB
    U440 (n418 n417 n411 inh_gnd inh_gnds inh_vdd inh_vdds) LVT_NOR2x1_PB4_AFBB
    U348 (B\<3\> B\<4\> n318 inh_gnd inh_gnds inh_vdd inh_vdds) LVT_NOR2x1_PB4_AFBB
    U347 (n316 n317 srl_res\<27\> inh_gnd inh_gnds inh_vdd inh_vdds) LVT_NOR2x1_PB4_AFBB
    U255 (n200 n146 n194 inh_gnd inh_gnds inh_vdd inh_vdds) LVT_NOR2x1_PB4_AFBB
    U251 (n195 n194 n193 inh_gnd inh_gnds inh_vdd inh_vdds) LVT_NOR2x1_PB4_AFBB
    U256 (n202 n201 n192 inh_gnd inh_gnds inh_vdd inh_vdds) LVT_NOR2x1_PB4_AFBB
    U412 (B\<4\> n287 srl_res\<19\> inh_gnd inh_gnds inh_vdd inh_vdds) LVT_NOR2x1_PB4_AFBB
    U375 (n344 n48 n348 inh_gnd inh_gnds inh_vdd inh_vdds) LVT_NOR2x1_PB4_AFBB
    U374 (n32 n142 n349 inh_gnd inh_gnds inh_vdd inh_vdds) LVT_NOR2x1_PB4_AFBB
    U373 (n348 n349 n346 inh_gnd inh_gnds inh_vdd inh_vdds) LVT_NOR2x1_PB4_AFBB
    U380 (n93 n355 n354 inh_gnd inh_gnds inh_vdd inh_vdds) LVT_NOR2x1_PB4_AFBB
    U381 (n44 n141 n353 inh_gnd inh_gnds inh_vdd inh_vdds) LVT_NOR2x1_PB4_AFBB
    U379 (n354 n353 n351 inh_gnd inh_gnds inh_vdd inh_vdds) LVT_NOR2x1_PB4_AFBB
    U367 (n341 n342 n339 inh_gnd inh_gnds inh_vdd inh_vdds) LVT_NOR2x1_PB4_AFBB
    U369 (n343 n157 n341 inh_gnd inh_gnds inh_vdd inh_vdds) LVT_NOR2x1_PB4_AFBB
    U368 (n143 n292 n342 inh_gnd inh_gnds inh_vdd inh_vdds) LVT_NOR2x1_PB4_AFBB
    U662 (n637 n638 n633 inh_gnd inh_gnds inh_vdd inh_vdds) LVT_NOR2x1_PB4_AFBB
    U664 (n84 n496 n637 inh_gnd inh_gnds inh_vdd inh_vdds) LVT_NOR2x1_PB4_AFBB
    U663 (n126 n123 n638 inh_gnd inh_gnds inh_vdd inh_vdds) LVT_NOR2x1_PB4_AFBB
    U661 (n136 n493 n635 inh_gnd inh_gnds inh_vdd inh_vdds) LVT_NOR2x1_PB4_AFBB
    U660 (n124 n18 n636 inh_gnd inh_gnds inh_vdd inh_vdds) LVT_NOR2x1_PB4_AFBB
    U659 (n635 n636 n634 inh_gnd inh_gnds inh_vdd inh_vdds) LVT_NOR2x1_PB4_AFBB
    U289 (n251 n250 n249 inh_gnd inh_gnds inh_vdd inh_vdds) LVT_NOR2x1_PB4_AFBB
    U294 (n256 n257 n248 inh_gnd inh_gnds inh_vdd inh_vdds) LVT_NOR2x1_PB4_AFBB
    U296 (n4 n200 n256 inh_gnd inh_gnds inh_vdd inh_vdds) LVT_NOR2x1_PB4_AFBB
    U634 (n84 n275 n613 inh_gnd inh_gnds inh_vdd inh_vdds) LVT_NOR2x1_PB4_AFBB
    U633 (n15 n92 n614 inh_gnd inh_gnds inh_vdd inh_vdds) LVT_NOR2x1_PB4_AFBB
    U632 (n613 n614 n609 inh_gnd inh_gnds inh_vdd inh_vdds) LVT_NOR2x1_PB4_AFBB
    U631 (n136 n54 n611 inh_gnd inh_gnds inh_vdd inh_vdds) LVT_NOR2x1_PB4_AFBB
    U630 (n269 n89 n612 inh_gnd inh_gnds inh_vdd inh_vdds) LVT_NOR2x1_PB4_AFBB
    U629 (n611 n612 n610 inh_gnd inh_gnds inh_vdd inh_vdds) LVT_NOR2x1_PB4_AFBB
    U502 (n28 n162 n477 inh_gnd inh_gnds inh_vdd inh_vdds) LVT_NOR2x1_PB4_AFBB
    U295 (n20 n162 n257 inh_gnd inh_gnds inh_vdd inh_vdds) LVT_NOR2x1_PB4_AFBB
    U607 (n592 n593 n591 inh_gnd inh_gnds inh_vdd inh_vdds) LVT_NOR2x1_PB4_AFBB
    U609 (n136 n281 n592 inh_gnd inh_gnds inh_vdd inh_vdds) LVT_NOR2x1_PB4_AFBB
    U293 (n164 n209 n250 inh_gnd inh_gnds inh_vdd inh_vdds) LVT_NOR2x1_PB4_AFBB
    U612 (n84 n120 n594 inh_gnd inh_gnds inh_vdd inh_vdds) LVT_NOR2x1_PB4_AFBB
    U611 (n10 n282 n595 inh_gnd inh_gnds inh_vdd inh_vdds) LVT_NOR2x1_PB4_AFBB
    U610 (n594 n595 n590 inh_gnd inh_gnds inh_vdd inh_vdds) LVT_NOR2x1_PB4_AFBB
    U608 (n124 n541 n593 inh_gnd inh_gnds inh_vdd inh_vdds) LVT_NOR2x1_PB4_AFBB
    U623 (n84 n540 n604 inh_gnd inh_gnds inh_vdd inh_vdds) LVT_NOR2x1_PB4_AFBB
    U622 (n155 n537 n605 inh_gnd inh_gnds inh_vdd inh_vdds) LVT_NOR2x1_PB4_AFBB
    U621 (n605 n604 n600 inh_gnd inh_gnds inh_vdd inh_vdds) LVT_NOR2x1_PB4_AFBB
    U620 (n136 n536 n602 inh_gnd inh_gnds inh_vdd inh_vdds) LVT_NOR2x1_PB4_AFBB
    U619 (n94 n75 n603 inh_gnd inh_gnds inh_vdd inh_vdds) LVT_NOR2x1_PB4_AFBB
    U618 (n602 n603 n601 inh_gnd inh_gnds inh_vdd inh_vdds) LVT_NOR2x1_PB4_AFBB
    U499 (n200 n150 n472 inh_gnd inh_gnds inh_vdd inh_vdds) LVT_NOR2x1_PB4_AFBB
    U495 (n473 n472 n471 inh_gnd inh_gnds inh_vdd inh_vdds) LVT_NOR2x1_PB4_AFBB
    U500 (n477 n478 n470 inh_gnd inh_gnds inh_vdd inh_vdds) LVT_NOR2x1_PB4_AFBB
    U501 (n30 n4 n478 inh_gnd inh_gnds inh_vdd inh_vdds) LVT_NOR2x1_PB4_AFBB
    U667 (n488 B\<3\> n336 inh_gnd inh_gnds inh_vdd inh_vdds) LVT_NOR2x1_PB4_AFBB
    U75 (B\<2\> B\<3\> n59 inh_gnd inh_gnds inh_vdd inh_vdds) LVT_NOR2x1_PB4_AFBB
    U559 (n93 n14 n176 inh_gnd inh_gnds inh_vdd inh_vdds) LVT_NOR2x1_PB4_AFBB
    U613 (n141 B\<4\> n207 inh_gnd inh_gnds inh_vdd inh_vdds) LVT_NOR2x1_PB4_AFBB
    U346 (n44 n150 srl_res\<28\> inh_gnd inh_gnds inh_vdd inh_vdds) LVT_NOR2x1_PB4_AFBB
    U655 (n84 n516 n631 inh_gnd inh_gnds inh_vdd inh_vdds) LVT_NOR2x1_PB4_AFBB
    U654 (n152 n79 n632 inh_gnd inh_gnds inh_vdd inh_vdds) LVT_NOR2x1_PB4_AFBB
    U653 (n631 n632 n627 inh_gnd inh_gnds inh_vdd inh_vdds) LVT_NOR2x1_PB4_AFBB
    U652 (n136 n116 n629 inh_gnd inh_gnds inh_vdd inh_vdds) LVT_NOR2x1_PB4_AFBB
    U651 (n124 n497 n630 inh_gnd inh_gnds inh_vdd inh_vdds) LVT_NOR2x1_PB4_AFBB
    U650 (n629 n630 n628 inh_gnd inh_gnds inh_vdd inh_vdds) LVT_NOR2x1_PB4_AFBB
    U569 (n231 n167 n544 inh_gnd inh_gnds inh_vdd inh_vdds) LVT_NOR2x1_PB4_AFBB
    U577 (n563 n562 n542 inh_gnd inh_gnds inh_vdd inh_vdds) LVT_NOR2x1_PB4_AFBB
    U595 (n149 n234 n562 inh_gnd inh_gnds inh_vdd inh_vdds) LVT_NOR2x1_PB4_AFBB
    U553 (n545 n544 n543 inh_gnd inh_gnds inh_vdd inh_vdds) LVT_NOR2x1_PB4_AFBB
    U249 (n167 n51 n182 inh_gnd inh_gnds inh_vdd inh_vdds) LVT_NOR2x1_PB4_AFBB
    U245 (n182 n183 n170 inh_gnd inh_gnds inh_vdd inh_vdds) LVT_NOR2x1_PB4_AFBB
    U240 (n173 n172 n171 inh_gnd inh_gnds inh_vdd inh_vdds) LVT_NOR2x1_PB4_AFBB
    U444 (n421 n422 n420 inh_gnd inh_gnds inh_vdd inh_vdds) LVT_NOR2x1_PB4_AFBB
    U451 (n210 n235 n427 inh_gnd inh_gnds inh_vdd inh_vdds) LVT_NOR2x1_PB4_AFBB
    U450 (n181 n402 n428 inh_gnd inh_gnds inh_vdd inh_vdds) LVT_NOR2x1_PB4_AFBB
    U449 (n427 n428 n419 inh_gnd inh_gnds inh_vdd inh_vdds) LVT_NOR2x1_PB4_AFBB
    U567 (n84 n117 n554 inh_gnd inh_gnds inh_vdd inh_vdds) LVT_NOR2x1_PB4_AFBB
    U566 (n152 n77 n555 inh_gnd inh_gnds inh_vdd inh_vdds) LVT_NOR2x1_PB4_AFBB
    U565 (n554 n555 n550 inh_gnd inh_gnds inh_vdd inh_vdds) LVT_NOR2x1_PB4_AFBB
    U564 (n136 n114 n552 inh_gnd inh_gnds inh_vdd inh_vdds) LVT_NOR2x1_PB4_AFBB
    U563 (n124 n121 n553 inh_gnd inh_gnds inh_vdd inh_vdds) LVT_NOR2x1_PB4_AFBB
    U562 (n552 n553 n551 inh_gnd inh_gnds inh_vdd inh_vdds) LVT_NOR2x1_PB4_AFBB
    U597 (n582 n581 n580 inh_gnd inh_gnds inh_vdd inh_vdds) LVT_NOR2x1_PB4_AFBB
    U599 (n136 n67 n581 inh_gnd inh_gnds inh_vdd inh_vdds) LVT_NOR2x1_PB4_AFBB
    U598 (n124 n65 n582 inh_gnd inh_gnds inh_vdd inh_vdds) LVT_NOR2x1_PB4_AFBB
    U600 (n583 n584 n579 inh_gnd inh_gnds inh_vdd inh_vdds) LVT_NOR2x1_PB4_AFBB
    U602 (n84 n71 n583 inh_gnd inh_gnds inh_vdd inh_vdds) LVT_NOR2x1_PB4_AFBB
    U601 (n55 n69 n584 inh_gnd inh_gnds inh_vdd inh_vdds) LVT_NOR2x1_PB4_AFBB
    U448 (n168 n343 n421 inh_gnd inh_gnds inh_vdd inh_vdds) LVT_NOR2x1_PB4_AFBB
    U586 (n84 n106 n570 inh_gnd inh_gnds inh_vdd inh_vdds) LVT_NOR2x1_PB4_AFBB
    U585 (n154 n81 n571 inh_gnd inh_gnds inh_vdd inh_vdds) LVT_NOR2x1_PB4_AFBB
    U584 (n570 n571 n566 inh_gnd inh_gnds inh_vdd inh_vdds) LVT_NOR2x1_PB4_AFBB
    U583 (n136 n40 n568 inh_gnd inh_gnds inh_vdd inh_vdds) LVT_NOR2x1_PB4_AFBB
    U582 (n94 n513 n569 inh_gnd inh_gnds inh_vdd inh_vdds) LVT_NOR2x1_PB4_AFBB
    U581 (n568 n569 n567 inh_gnd inh_gnds inh_vdd inh_vdds) LVT_NOR2x1_PB4_AFBB
    U435 (n414 n413 n412 inh_gnd inh_gnds inh_vdd inh_vdds) LVT_NOR2x1_PB4_AFBB
    U524 (n504 n505 n498 inh_gnd inh_gnds inh_vdd inh_vdds) LVT_NOR2x1_PB4_AFBB
    U526 (n84 n109 n504 inh_gnd inh_gnds inh_vdd inh_vdds) LVT_NOR2x1_PB4_AFBB
    U439 (n33 n145 n413 inh_gnd inh_gnds inh_vdd inh_vdds) LVT_NOR2x1_PB4_AFBB
    U321 (n35 n148 srl_res\<30\> inh_gnd inh_gnds inh_vdd inh_vdds) LVT_NOR2x1_PB4_AFBB
    U277 (n145 n234 n233 inh_gnd inh_gnds inh_vdd inh_vdds) LVT_NOR2x1_PB4_AFBB
    U74 (B\<2\> B\<3\> n58 inh_gnd inh_gnds inh_vdd inh_vdds) LVT_NOR2x1_PB4_AFBB
    U320 (n148 n23 srl_res\<31\> inh_gnd inh_gnds inh_vdd inh_vdds) LVT_NOR2x1_PB4_AFBB
    U454 (n435 n436 n434 inh_gnd inh_gnds inh_vdd inh_vdds) LVT_NOR2x1_PB4_AFBB
    U455 (n138 n32 n436 inh_gnd inh_gnds inh_vdd inh_vdds) LVT_NOR2x1_PB4_AFBB
    U244 (n162 n47 n172 inh_gnd inh_gnds inh_vdd inh_vdds) LVT_NOR2x1_PB4_AFBB
    U461 (n169 n48 n435 inh_gnd inh_gnds inh_vdd inh_vdds) LVT_NOR2x1_PB4_AFBB
    U460 (n136 n443 n440 inh_gnd inh_gnds inh_vdd inh_vdds) LVT_NOR2x1_PB4_AFBB
    U459 (n84 n442 n441 inh_gnd inh_gnds inh_vdd inh_vdds) LVT_NOR2x1_PB4_AFBB
    U458 (n440 n441 n438 inh_gnd inh_gnds inh_vdd inh_vdds) LVT_NOR2x1_PB4_AFBB
    U516 (n494 n495 n489 inh_gnd inh_gnds inh_vdd inh_vdds) LVT_NOR2x1_PB4_AFBB
    U518 (n84 n78 n494 inh_gnd inh_gnds inh_vdd inh_vdds) LVT_NOR2x1_PB4_AFBB
    U517 (n153 n115 n495 inh_gnd inh_gnds inh_vdd inh_vdds) LVT_NOR2x1_PB4_AFBB
    U515 (n136 n122 n491 inh_gnd inh_gnds inh_vdd inh_vdds) LVT_NOR2x1_PB4_AFBB
    U514 (n94 n9 n492 inh_gnd inh_gnds inh_vdd inh_vdds) LVT_NOR2x1_PB4_AFBB
    U513 (n491 n492 n490 inh_gnd inh_gnds inh_vdd inh_vdds) LVT_NOR2x1_PB4_AFBB
    U276 (n232 n233 n223 inh_gnd inh_gnds inh_vdd inh_vdds) LVT_NOR2x1_PB4_AFBB
    U589 (n574 n575 n573 inh_gnd inh_gnds inh_vdd inh_vdds) LVT_NOR2x1_PB4_AFBB
    U591 (n136 n104 n574 inh_gnd inh_gnds inh_vdd inh_vdds) LVT_NOR2x1_PB4_AFBB
    U278 (n191 n235 n232 inh_gnd inh_gnds inh_vdd inh_vdds) LVT_NOR2x1_PB4_AFBB
    U594 (n84 n63 n576 inh_gnd inh_gnds inh_vdd inh_vdds) LVT_NOR2x1_PB4_AFBB
    U593 (n155 n530 n577 inh_gnd inh_gnds inh_vdd inh_vdds) LVT_NOR2x1_PB4_AFBB
    U592 (n577 n576 n572 inh_gnd inh_gnds inh_vdd inh_vdds) LVT_NOR2x1_PB4_AFBB
    U530 (n269 n512 n511 inh_gnd inh_gnds inh_vdd inh_vdds) LVT_NOR2x1_PB4_AFBB
    U590 (n269 n102 n575 inh_gnd inh_gnds inh_vdd inh_vdds) LVT_NOR2x1_PB4_AFBB
    U531 (n136 n80 n510 inh_gnd inh_gnds inh_vdd inh_vdds) LVT_NOR2x1_PB4_AFBB
    U529 (n511 n510 n509 inh_gnd inh_gnds inh_vdd inh_vdds) LVT_NOR2x1_PB4_AFBB
    U534 (n84 n82 n514 inh_gnd inh_gnds inh_vdd inh_vdds) LVT_NOR2x1_PB4_AFBB
    U533 (n125 n41 n515 inh_gnd inh_gnds inh_vdd inh_vdds) LVT_NOR2x1_PB4_AFBB
    U532 (n515 n514 n508 inh_gnd inh_gnds inh_vdd inh_vdds) LVT_NOR2x1_PB4_AFBB
    U271 (n226 n225 n224 inh_gnd inh_gnds inh_vdd inh_vdds) LVT_NOR2x1_PB4_AFBB
    U275 (n231 n1 n225 inh_gnd inh_gnds inh_vdd inh_vdds) LVT_NOR2x1_PB4_AFBB
    U340 (n84 n53 n311 inh_gnd inh_gnds inh_vdd inh_vdds) LVT_NOR2x1_PB4_AFBB
    U338 (n311 n312 n307 inh_gnd inh_gnds inh_vdd inh_vdds) LVT_NOR2x1_PB4_AFBB
    U576 (n84 n61 n560 inh_gnd inh_gnds inh_vdd inh_vdds) LVT_NOR2x1_PB4_AFBB
    U575 (n15 n108 n561 inh_gnd inh_gnds inh_vdd inh_vdds) LVT_NOR2x1_PB4_AFBB
    U574 (n560 n561 n556 inh_gnd inh_gnds inh_vdd inh_vdds) LVT_NOR2x1_PB4_AFBB
    U573 (n136 n73 n558 inh_gnd inh_gnds inh_vdd inh_vdds) LVT_NOR2x1_PB4_AFBB
    U572 (n94 n110 n559 inh_gnd inh_gnds inh_vdd inh_vdds) LVT_NOR2x1_PB4_AFBB
    U571 (n558 n559 n557 inh_gnd inh_gnds inh_vdd inh_vdds) LVT_NOR2x1_PB4_AFBB
    U339 (n154 n88 n312 inh_gnd inh_gnds inh_vdd inh_vdds) LVT_NOR2x1_PB4_AFBB
    U337 (n136 n119 n309 inh_gnd inh_gnds inh_vdd inh_vdds) LVT_NOR2x1_PB4_AFBB
    U336 (n94 n112 n310 inh_gnd inh_gnds inh_vdd inh_vdds) LVT_NOR2x1_PB4_AFBB
    U335 (n310 n309 n308 inh_gnd inh_gnds inh_vdd inh_vdds) LVT_NOR2x1_PB4_AFBB
    U523 (n136 n111 n500 inh_gnd inh_gnds inh_vdd inh_vdds) LVT_NOR2x1_PB4_AFBB
    U521 (n500 n501 n499 inh_gnd inh_gnds inh_vdd inh_vdds) LVT_NOR2x1_PB4_AFBB
    U522 (n94 n107 n501 inh_gnd inh_gnds inh_vdd inh_vdds) LVT_NOR2x1_PB4_AFBB
    U10 (B\<0\> B\<1\> n5 inh_gnd inh_gnds inh_vdd inh_vdds) LVT_NOR2x1_PB4_AFBB
    U525 (n125 n74 n505 inh_gnd inh_gnds inh_vdd inh_vdds) LVT_NOR2x1_PB4_AFBB
    U677 (n647 n648 n208 inh_gnd inh_gnds inh_vdd inh_vdds) LVT_NADN2x1_PB4_AFBB
    U360 (n330 n331 n329 inh_gnd inh_gnds inh_vdd inh_vdds) LVT_NADN2x1_PB4_AFBB
    U359 (n329 n328 n218 inh_gnd inh_gnds inh_vdd inh_vdds) LVT_NADN2x1_PB4_AFBB
    U362 (n335 n158 n334 inh_gnd inh_gnds inh_vdd inh_vdds) LVT_NADN2x1_PB4_AFBB
    U603 (n585 n586 C\<0\> inh_gnd inh_gnds inh_vdd inh_vdds) LVT_NADN2x1_PB4_AFBB
    U626 (n144 n255 n608 inh_gnd inh_gnds inh_vdd inh_vdds) LVT_NADN2x1_PB4_AFBB
    U616 (n476 n127 n599 inh_gnd inh_gnds inh_vdd inh_vdds) LVT_NADN2x1_PB4_AFBB
    U615 (n599 n598 n597 inh_gnd inh_gnds inh_vdd inh_vdds) LVT_NADN2x1_PB4_AFBB
    U643 (A\<3\> n160 n620 inh_gnd inh_gnds inh_vdd inh_vdds) LVT_NADN2x1_PB4_AFBB
    U642 (A\<2\> n137 n621 inh_gnd inh_gnds inh_vdd inh_vdds) LVT_NADN2x1_PB4_AFBB
    U641 (n620 n621 n616 inh_gnd inh_gnds inh_vdd inh_vdds) LVT_NADN2x1_PB4_AFBB
    U640 (A\<1\> n97 n618 inh_gnd inh_gnds inh_vdd inh_vdds) LVT_NADN2x1_PB4_AFBB
    U639 (A\<0\> n85 n619 inh_gnd inh_gnds inh_vdd inh_vdds) LVT_NADN2x1_PB4_AFBB
    U638 (n618 n619 n617 inh_gnd inh_gnds inh_vdd inh_vdds) LVT_NADN2x1_PB4_AFBB
    U645 (n623 n624 n622 inh_gnd inh_gnds inh_vdd inh_vdds) LVT_NADN2x1_PB4_AFBB
    U419 (n395 n396 n394 inh_gnd inh_gnds inh_vdd inh_vdds) LVT_NADN2x1_PB4_AFBB
    U322 (n293 n294 srl_res\<2\> inh_gnd inh_gnds inh_vdd inh_vdds) LVT_NADN2x1_PB4_AFBB
    U324 (n297 n298 n296 inh_gnd inh_gnds inh_vdd inh_vdds) LVT_NADN2x1_PB4_AFBB
    U333 (n165 n229 n297 inh_gnd inh_gnds inh_vdd inh_vdds) LVT_NADN2x1_PB4_AFBB
    U326 (n300 n301 n299 inh_gnd inh_gnds inh_vdd inh_vdds) LVT_NADN2x1_PB4_AFBB
    U325 (n299 n147 n298 inh_gnd inh_gnds inh_vdd inh_vdds) LVT_NADN2x1_PB4_AFBB
    U332 (n132 A\<2\> n306 inh_gnd inh_gnds inh_vdd inh_vdds) LVT_NADN2x1_PB4_AFBB
    U427 (n404 n405 n403 inh_gnd inh_gnds inh_vdd inh_vdds) LVT_NADN2x1_PB4_AFBB
    U657 (B\<3\> B\<2\> n399 inh_gnd inh_gnds inh_vdd inh_vdds) LVT_NADN2x1_PB4_AFBB
    U680 (B\<0\> B\<1\> n269 inh_gnd inh_gnds inh_vdd inh_vdds) LVT_NADN2x1_PB4_AFBB
    U382 (n356 n357 srl_res\<1\> inh_gnd inh_gnds inh_vdd inh_vdds) LVT_NADN2x1_PB4_AFBB
    U383 (n359 n360 n358 inh_gnd inh_gnds inh_vdd inh_vdds) LVT_NADN2x1_PB4_AFBB
    U401 (n165 n245 n359 inh_gnd inh_gnds inh_vdd inh_vdds) LVT_NADN2x1_PB4_AFBB
    U392 (A\<1\> n85 n369 inh_gnd inh_gnds inh_vdd inh_vdds) LVT_NADN2x1_PB4_AFBB
    U391 (n96 A\<2\> n370 inh_gnd inh_gnds inh_vdd inh_vdds) LVT_NADN2x1_PB4_AFBB
    U390 (n369 n370 n364 inh_gnd inh_gnds inh_vdd inh_vdds) LVT_NADN2x1_PB4_AFBB
    U389 (A\<3\> n368 n366 inh_gnd inh_gnds inh_vdd inh_vdds) LVT_NADN2x1_PB4_AFBB
    U388 (A\<4\> n160 n367 inh_gnd inh_gnds inh_vdd inh_vdds) LVT_NADN2x1_PB4_AFBB
    U387 (n366 n367 n365 inh_gnd inh_gnds inh_vdd inh_vdds) LVT_NADN2x1_PB4_AFBB
    U482 (A\<17\> n85 n460 inh_gnd inh_gnds inh_vdd inh_vdds) LVT_NADN2x1_PB4_AFBB
    U481 (A\<18\> n98 n461 inh_gnd inh_gnds inh_vdd inh_vdds) LVT_NADN2x1_PB4_AFBB
    U397 (A\<9\> n132 n374 inh_gnd inh_gnds inh_vdd inh_vdds) LVT_NADN2x1_PB4_AFBB
    U395 (n374 n375 n373 inh_gnd inh_gnds inh_vdd inh_vdds) LVT_NADN2x1_PB4_AFBB
    U396 (A\<10\> n98 n375 inh_gnd inh_gnds inh_vdd inh_vdds) LVT_NADN2x1_PB4_AFBB
    U480 (n460 n461 n459 inh_gnd inh_gnds inh_vdd inh_vdds) LVT_NADN2x1_PB4_AFBB
    U484 (A\<20\> n160 n463 inh_gnd inh_gnds inh_vdd inh_vdds) LVT_NADN2x1_PB4_AFBB
    U485 (A\<19\> n86 n462 inh_gnd inh_gnds inh_vdd inh_vdds) LVT_NADN2x1_PB4_AFBB
    U483 (n462 n463 n458 inh_gnd inh_gnds inh_vdd inh_vdds) LVT_NADN2x1_PB4_AFBB
    U492 (A\<16\> n160 n469 inh_gnd inh_gnds inh_vdd inh_vdds) LVT_NADN2x1_PB4_AFBB
    U493 (A\<15\> n137 n468 inh_gnd inh_gnds inh_vdd inh_vdds) LVT_NADN2x1_PB4_AFBB
    U465 (A\<23\> n137 n446 inh_gnd inh_gnds inh_vdd inh_vdds) LVT_NADN2x1_PB4_AFBB
    U491 (n468 n469 n464 inh_gnd inh_gnds inh_vdd inh_vdds) LVT_NADN2x1_PB4_AFBB
    U490 (A\<13\> n132 n466 inh_gnd inh_gnds inh_vdd inh_vdds) LVT_NADN2x1_PB4_AFBB
    U489 (n97 A\<14\> n467 inh_gnd inh_gnds inh_vdd inh_vdds) LVT_NADN2x1_PB4_AFBB
    U488 (n466 n467 n465 inh_gnd inh_gnds inh_vdd inh_vdds) LVT_NADN2x1_PB4_AFBB
    U464 (A\<24\> n160 n447 inh_gnd inh_gnds inh_vdd inh_vdds) LVT_NADN2x1_PB4_AFBB
    U463 (n446 n447 n445 inh_gnd inh_gnds inh_vdd inh_vdds) LVT_NADN2x1_PB4_AFBB
    U468 (A\<21\> n132 n448 inh_gnd inh_gnds inh_vdd inh_vdds) LVT_NADN2x1_PB4_AFBB
    U467 (n97 A\<22\> n449 inh_gnd inh_gnds inh_vdd inh_vdds) LVT_NADN2x1_PB4_AFBB
    U466 (n448 n449 n444 inh_gnd inh_gnds inh_vdd inh_vdds) LVT_NADN2x1_PB4_AFBB
    U472 (A\<26\> n96 n453 inh_gnd inh_gnds inh_vdd inh_vdds) LVT_NADN2x1_PB4_AFBB
    U473 (A\<25\> n132 n452 inh_gnd inh_gnds inh_vdd inh_vdds) LVT_NADN2x1_PB4_AFBB
    U469 (n83 n179 n433 inh_gnd inh_gnds inh_vdd inh_vdds) LVT_NADN2x1_PB4_AFBB
    U471 (n452 n453 n451 inh_gnd inh_gnds inh_vdd inh_vdds) LVT_NADN2x1_PB4_AFBB
    U476 (A\<27\> n86 n454 inh_gnd inh_gnds inh_vdd inh_vdds) LVT_NADN2x1_PB4_AFBB
    U475 (A\<28\> n160 n455 inh_gnd inh_gnds inh_vdd inh_vdds) LVT_NADN2x1_PB4_AFBB
    U474 (n454 n455 n450 inh_gnd inh_gnds inh_vdd inh_vdds) LVT_NADN2x1_PB4_AFBB
    U400 (A\<11\> n86 n376 inh_gnd inh_gnds inh_vdd inh_vdds) LVT_NADN2x1_PB4_AFBB
    U399 (A\<12\> n160 n377 inh_gnd inh_gnds inh_vdd inh_vdds) LVT_NADN2x1_PB4_AFBB
    U398 (n376 n377 n372 inh_gnd inh_gnds inh_vdd inh_vdds) LVT_NADN2x1_PB4_AFBB
    U283 (n186 n144 n240 inh_gnd inh_gnds inh_vdd inh_vdds) LVT_NADN2x1_PB4_AFBB
    U281 (n240 n241 n239 inh_gnd inh_gnds inh_vdd inh_vdds) LVT_NADN2x1_PB4_AFBB
    U282 (B\<4\> n242 n241 inh_gnd inh_gnds inh_vdd inh_vdds) LVT_NADN2x1_PB4_AFBB
    U279 (n236 n237 srl_res\<5\> inh_gnd inh_gnds inh_vdd inh_vdds) LVT_NADN2x1_PB4_AFBB
    U284 (n100 n245 n244 inh_gnd inh_gnds inh_vdd inh_vdds) LVT_NADN2x1_PB4_AFBB
    U402 (n378 n379 n245 inh_gnd inh_gnds inh_vdd inh_vdds) LVT_NADN2x1_PB4_AFBB
    U452 (n430 n431 srl_res\<13\> inh_gnd inh_gnds inh_vdd inh_vdds) LVT_NADN2x1_PB4_AFBB
    U453 (n433 n434 n432 inh_gnd inh_gnds inh_vdd inh_vdds) LVT_NADN2x1_PB4_AFBB
    U685 (B\<0\> n651 n274 inh_gnd inh_gnds inh_vdd inh_vdds) LVT_NADN2x1_PB4_AFBB
    U558 (A\<31\> n96 n548 inh_gnd inh_gnds inh_vdd inh_vdds) LVT_NADN2x1_PB4_AFBB
    U556 (n548 n549 n321 inh_gnd inh_gnds inh_vdd inh_vdds) LVT_NADN2x1_PB4_AFBB
    U557 (A\<30\> n85 n549 inh_gnd inh_gnds inh_vdd inh_vdds) LVT_NADN2x1_PB4_AFBB
    U509 (B\<2\> n22 n487 inh_gnd inh_gnds inh_vdd inh_vdds) LVT_NADN2x1_PB4_AFBB
    U508 (n486 n487 n393 inh_gnd inh_gnds inh_vdd inh_vdds) LVT_NADN2x1_PB4_AFBB
    U511 (n17 n335 n486 inh_gnd inh_gnds inh_vdd inh_vdds) LVT_NADN2x1_PB4_AFBB
    U510 (A\<31\> n85 n291 inh_gnd inh_gnds inh_vdd inh_vdds) LVT_NADN2x1_PB4_AFBB
    U246 (n184 n185 n183 inh_gnd inh_gnds inh_vdd inh_vdds) LVT_NADN2x1_PB4_AFBB
    U247 (n101 n186 n185 inh_gnd inh_gnds inh_vdd inh_vdds) LVT_NADN2x1_PB4_AFBB
    U668 (n641 n642 n206 inh_gnd inh_gnds inh_vdd inh_vdds) LVT_NADN2x1_PB4_AFBB
    U506 (n485 B\<4\> n484 inh_gnd inh_gnds inh_vdd inh_vdds) LVT_NADN2x1_PB4_AFBB
    U505 (n483 n484 n482 inh_gnd inh_gnds inh_vdd inh_vdds) LVT_NADN2x1_PB4_AFBB
    U519 (n27 n34 n483 inh_gnd inh_gnds inh_vdd inh_vdds) LVT_NADN2x1_PB4_AFBB
    U503 (n479 n480 srl_res\<11\> inh_gnd inh_gnds inh_vdd inh_vdds) LVT_NADN2x1_PB4_AFBB
    U417 (B\<3\> n393 n390 inh_gnd inh_gnds inh_vdd inh_vdds) LVT_NADN2x1_PB4_AFBB
    U416 (n34 n156 n391 inh_gnd inh_gnds inh_vdd inh_vdds) LVT_NADN2x1_PB4_AFBB
    U568 (B\<4\> n156 n437 inh_gnd inh_gnds inh_vdd inh_vdds) LVT_NADN2x1_PB4_AFBB
    U415 (n390 n391 n387 inh_gnd inh_gnds inh_vdd inh_vdds) LVT_NADN2x1_PB4_AFBB
    U297 (n258 n259 srl_res\<3\> inh_gnd inh_gnds inh_vdd inh_vdds) LVT_NADN2x1_PB4_AFBB
    U299 (n262 n263 n261 inh_gnd inh_gnds inh_vdd inh_vdds) LVT_NADN2x1_PB4_AFBB
    U308 (n217 n144 n262 inh_gnd inh_gnds inh_vdd inh_vdds) LVT_NADN2x1_PB4_AFBB
    U301 (n265 n266 n264 inh_gnd inh_gnds inh_vdd inh_vdds) LVT_NADN2x1_PB4_AFBB
    U264 (n101 n217 n216 inh_gnd inh_gnds inh_vdd inh_vdds) LVT_NADN2x1_PB4_AFBB
    U300 (n101 n264 n263 inh_gnd inh_gnds inh_vdd inh_vdds) LVT_NADN2x1_PB4_AFBB
    U261 (n211 n212 srl_res\<7\> inh_gnd inh_gnds inh_vdd inh_vdds) LVT_NADN2x1_PB4_AFBB
    U545 (n532 n533 n531 inh_gnd inh_gnds inh_vdd inh_vdds) LVT_NADN2x1_PB4_AFBB
    U265 (B\<4\> n218 n215 inh_gnd inh_gnds inh_vdd inh_vdds) LVT_NADN2x1_PB4_AFBB
    U263 (n216 n215 n214 inh_gnd inh_gnds inh_vdd inh_vdds) LVT_NADN2x1_PB4_AFBB
    U358 (n130 n218 n327 inh_gnd inh_gnds inh_vdd inh_vdds) LVT_NADN2x1_PB4_AFBB
    U309 (n277 n278 n217 inh_gnd inh_gnds inh_vdd inh_vdds) LVT_NADN2x1_PB4_AFBB
    U537 (n521 n522 n520 inh_gnd inh_gnds inh_vdd inh_vdds) LVT_NADN2x1_PB4_AFBB
    U434 (n411 n412 srl_res\<15\> inh_gnd inh_gnds inh_vdd inh_vdds) LVT_NADN2x1_PB4_AFBB
    U250 (n192 n193 srl_res\<8\> inh_gnd inh_gnds inh_vdd inh_vdds) LVT_NADN2x1_PB4_AFBB
    U371 (n347 n346 n242 inh_gnd inh_gnds inh_vdd inh_vdds) LVT_NADN2x1_PB4_AFBB
    U372 (n336 n179 n347 inh_gnd inh_gnds inh_vdd inh_vdds) LVT_NADN2x1_PB4_AFBB
    U370 (n288 n242 n345 inh_gnd inh_gnds inh_vdd inh_vdds) LVT_NADN2x1_PB4_AFBB
    U378 (n31 n156 n352 inh_gnd inh_gnds inh_vdd inh_vdds) LVT_NADN2x1_PB4_AFBB
    U377 (n352 n351 n254 inh_gnd inh_gnds inh_vdd inh_vdds) LVT_NADN2x1_PB4_AFBB
    U357 (n100 n29 n325 inh_gnd inh_gnds inh_vdd inh_vdds) LVT_NADN2x1_PB4_AFBB
    U355 (n325 n326 srl_res\<24\> inh_gnd inh_gnds inh_vdd inh_vdds) LVT_NADN2x1_PB4_AFBB
    U365 (n340 n339 n230 inh_gnd inh_gnds inh_vdd inh_vdds) LVT_NADN2x1_PB4_AFBB
    U366 (n25 n158 n340 inh_gnd inh_gnds inh_vdd inh_vdds) LVT_NADN2x1_PB4_AFBB
    U351 (n100 n25 n319 inh_gnd inh_gnds inh_vdd inh_vdds) LVT_NADN2x1_PB4_AFBB
    U627 (n158 n8 n188 inh_gnd inh_gnds inh_vdd inh_vdds) LVT_NADN2x1_PB4_AFBB
    U350 (n36 n144 n320 inh_gnd inh_gnds inh_vdd inh_vdds) LVT_NADN2x1_PB4_AFBB
    U349 (n319 n320 srl_res\<26\> inh_gnd inh_gnds inh_vdd inh_vdds) LVT_NADN2x1_PB4_AFBB
    U356 (n45 n165 n326 inh_gnd inh_gnds inh_vdd inh_vdds) LVT_NADN2x1_PB4_AFBB
    U658 (n633 n634 n198 inh_gnd inh_gnds inh_vdd inh_vdds) LVT_NADN2x1_PB4_AFBB
    U291 (B\<4\> n254 n253 inh_gnd inh_gnds inh_vdd inh_vdds) LVT_NADN2x1_PB4_AFBB
    U288 (n248 n249 srl_res\<4\> inh_gnd inh_gnds inh_vdd inh_vdds) LVT_NADN2x1_PB4_AFBB
    U290 (n252 n253 n251 inh_gnd inh_gnds inh_vdd inh_vdds) LVT_NADN2x1_PB4_AFBB
    U628 (n609 n610 n255 inh_gnd inh_gnds inh_vdd inh_vdds) LVT_NADN2x1_PB4_AFBB
    U292 (n147 n255 n252 inh_gnd inh_gnds inh_vdd inh_vdds) LVT_NADN2x1_PB4_AFBB
    U606 (n590 n591 n589 inh_gnd inh_gnds inh_vdd inh_vdds) LVT_NADN2x1_PB4_AFBB
    U617 (n600 n601 n476 inh_gnd inh_gnds inh_vdd inh_vdds) LVT_NADN2x1_PB4_AFBB
    U494 (n470 n471 srl_res\<12\> inh_gnd inh_gnds inh_vdd inh_vdds) LVT_NADN2x1_PB4_AFBB
    U648 (B\<3\> n16 n337 inh_gnd inh_gnds inh_vdd inh_vdds) LVT_NADN2x1_PB4_AFBB
    U376 (n131 n254 n350 inh_gnd inh_gnds inh_vdd inh_vdds) LVT_NADN2x1_PB4_AFBB
    U649 (n627 n628 n199 inh_gnd inh_gnds inh_vdd inh_vdds) LVT_NADN2x1_PB4_AFBB
    U552 (n542 n543 srl_res\<10\> inh_gnd inh_gnds inh_vdd inh_vdds) LVT_NADN2x1_PB4_AFBB
    U555 (n321 n176 n547 inh_gnd inh_gnds inh_vdd inh_vdds) LVT_NADN2x1_PB4_AFBB
    U560 (n178 n322 n546 inh_gnd inh_gnds inh_vdd inh_vdds) LVT_NADN2x1_PB4_AFBB
    U554 (n547 n546 n545 inh_gnd inh_gnds inh_vdd inh_vdds) LVT_NADN2x1_PB4_AFBB
    U254 (n139 n29 n196 inh_gnd inh_gnds inh_vdd inh_vdds) LVT_NADN2x1_PB4_AFBB
    U252 (n196 n197 n195 inh_gnd inh_gnds inh_vdd inh_vdds) LVT_NADN2x1_PB4_AFBB
    U253 (n45 n176 n197 inh_gnd inh_gnds inh_vdd inh_vdds) LVT_NADN2x1_PB4_AFBB
    U497 (n45 n139 n475 inh_gnd inh_gnds inh_vdd inh_vdds) LVT_NADN2x1_PB4_AFBB
    U498 (n21 n144 n474 inh_gnd inh_gnds inh_vdd inh_vdds) LVT_NADN2x1_PB4_AFBB
    U259 (n27 n21 n203 inh_gnd inh_gnds inh_vdd inh_vdds) LVT_NADN2x1_PB4_AFBB
    U257 (n203 n204 n202 inh_gnd inh_gnds inh_vdd inh_vdds) LVT_NADN2x1_PB4_AFBB
    U258 (n31 n161 n204 inh_gnd inh_gnds inh_vdd inh_vdds) LVT_NADN2x1_PB4_AFBB
    U579 (n161 n426 n565 inh_gnd inh_gnds inh_vdd inh_vdds) LVT_NADN2x1_PB4_AFBB
    U496 (n474 n475 n473 inh_gnd inh_gnds inh_vdd inh_vdds) LVT_NADN2x1_PB4_AFBB
    U587 (n429 n144 n564 inh_gnd inh_gnds inh_vdd inh_vdds) LVT_NADN2x1_PB4_AFBB
    U578 (n564 n565 n563 inh_gnd inh_gnds inh_vdd inh_vdds) LVT_NADN2x1_PB4_AFBB
    U239 (n170 n171 srl_res\<9\> inh_gnd inh_gnds inh_vdd inh_vdds) LVT_NADN2x1_PB4_AFBB
    U242 (n176 n177 n175 inh_gnd inh_gnds inh_vdd inh_vdds) LVT_NADN2x1_PB4_AFBB
    U243 (n139 n179 n174 inh_gnd inh_gnds inh_vdd inh_vdds) LVT_NADN2x1_PB4_AFBB
    U354 (n101 n179 n323 inh_gnd inh_gnds inh_vdd inh_vdds) LVT_NADN2x1_PB4_AFBB
    U352 (n323 n324 srl_res\<25\> inh_gnd inh_gnds inh_vdd inh_vdds) LVT_NADN2x1_PB4_AFBB
    U241 (n175 n174 n173 inh_gnd inh_gnds inh_vdd inh_vdds) LVT_NADN2x1_PB4_AFBB
    U447 (n165 n425 n423 inh_gnd inh_gnds inh_vdd inh_vdds) LVT_NADN2x1_PB4_AFBB
    U353 (n165 n177 n324 inh_gnd inh_gnds inh_vdd inh_vdds) LVT_NADN2x1_PB4_AFBB
    U446 (n178 n36 n424 inh_gnd inh_gnds inh_vdd inh_vdds) LVT_NADN2x1_PB4_AFBB
    U443 (n419 n420 srl_res\<14\> inh_gnd inh_gnds inh_vdd inh_vdds) LVT_NADN2x1_PB4_AFBB
    U445 (n423 n424 n422 inh_gnd inh_gnds inh_vdd inh_vdds) LVT_NADN2x1_PB4_AFBB
    U561 (n550 n551 n322 inh_gnd inh_gnds inh_vdd inh_vdds) LVT_NADN2x1_PB4_AFBB
    U596 (n579 n580 n578 inh_gnd inh_gnds inh_vdd inh_vdds) LVT_NADN2x1_PB4_AFBB
    U580 (n566 n567 n426 inh_gnd inh_gnds inh_vdd inh_vdds) LVT_NADN2x1_PB4_AFBB
    U520 (n498 n499 n392 inh_gnd inh_gnds inh_vdd inh_vdds) LVT_NADN2x1_PB4_AFBB
    U636 (n58 n128 n210 inh_gnd inh_gnds inh_vdd inh_vdds) LVT_NADN2x1_PB4_AFBB
    U436 (n415 n416 n414 inh_gnd inh_gnds inh_vdd inh_vdds) LVT_NADN2x1_PB4_AFBB
    U437 (n139 n22 n416 inh_gnd inh_gnds inh_vdd inh_vdds) LVT_NADN2x1_PB4_AFBB
    U456 (n439 n438 n177 inh_gnd inh_gnds inh_vdd inh_vdds) LVT_NADN2x1_PB4_AFBB
    U457 (A\<30\> n98 n439 inh_gnd inh_gnds inh_vdd inh_vdds) LVT_NADN2x1_PB4_AFBB
    U512 (n489 n490 n335 inh_gnd inh_gnds inh_vdd inh_vdds) LVT_NADN2x1_PB4_AFBB
    U438 (n335 n83 n415 inh_gnd inh_gnds inh_vdd inh_vdds) LVT_NADN2x1_PB4_AFBB
    U270 (n223 n224 srl_res\<6\> inh_gnd inh_gnds inh_vdd inh_vdds) LVT_NADN2x1_PB4_AFBB
    U588 (n572 n573 n429 inh_gnd inh_gnds inh_vdd inh_vdds) LVT_NADN2x1_PB4_AFBB
    U528 (n508 n509 n331 inh_gnd inh_gnds inh_vdd inh_vdds) LVT_NADN2x1_PB4_AFBB
    U274 (B\<4\> n230 n227 inh_gnd inh_gnds inh_vdd inh_vdds) LVT_NADN2x1_PB4_AFBB
    U272 (n227 n228 n226 inh_gnd inh_gnds inh_vdd inh_vdds) LVT_NADN2x1_PB4_AFBB
    U364 (n129 n230 n338 inh_gnd inh_gnds inh_vdd inh_vdds) LVT_NADN2x1_PB4_AFBB
    U570 (n556 n557 n425 inh_gnd inh_gnds inh_vdd inh_vdds) LVT_NADN2x1_PB4_AFBB
    U334 (n307 n308 n229 inh_gnd inh_gnds inh_vdd inh_vdds) LVT_NADN2x1_PB4_AFBB
    U273 (n101 n229 n228 inh_gnd inh_gnds inh_vdd inh_vdds) LVT_NADN2x1_PB4_AFBB
    Thru29 (srl_res\<1\> C\<1\>) iprobe
    Thru28 (srl_res\<2\> C\<2\>) iprobe
    Thru27 (srl_res\<3\> C\<3\>) iprobe
    Thru26 (srl_res\<4\> C\<4\>) iprobe
    Thru25 (srl_res\<5\> C\<5\>) iprobe
    Thru24 (srl_res\<6\> C\<6\>) iprobe
    Thru23 (srl_res\<7\> C\<7\>) iprobe
    Thru22 (srl_res\<8\> C\<8\>) iprobe
    Thru21 (srl_res\<9\> C\<9\>) iprobe
    Thru20 (srl_res\<10\> C\<10\>) iprobe
    Thru19 (srl_res\<11\> C\<11\>) iprobe
    Thru18 (srl_res\<12\> C\<12\>) iprobe
    Thru17 (srl_res\<13\> C\<13\>) iprobe
    Thru16 (srl_res\<14\> C\<14\>) iprobe
    Thru15 (srl_res\<15\> C\<15\>) iprobe
    Thru14 (srl_res\<17\> C\<17\>) iprobe
    Thru13 (srl_res\<18\> C\<18\>) iprobe
    Thru12 (srl_res\<19\> C\<19\>) iprobe
    Thru11 (srl_res\<20\> C\<20\>) iprobe
    Thru10 (srl_res\<21\> C\<21\>) iprobe
    Thru9 (srl_res\<22\> C\<22\>) iprobe
    Thru8 (srl_res\<23\> C\<23\>) iprobe
    Thru7 (srl_res\<24\> C\<24\>) iprobe
    Thru6 (srl_res\<25\> C\<25\>) iprobe
    Thru5 (srl_res\<26\> C\<26\>) iprobe
    Thru4 (srl_res\<27\> C\<27\>) iprobe
    Thru3 (srl_res\<28\> C\<28\>) iprobe
    Thru2 (srl_res\<29\> C\<29\>) iprobe
    Thru1 (srl_res\<30\> C\<30\>) iprobe
    Thru0 (srl_res\<31\> C\<31\>) iprobe
ends alu_srl

// power_gating_fine/alu_bpt/schematic
subckt alu_bpt pwr_en B\<31\> B\<30\> B\<29\> B\<28\> B\<27\> B\<26\> B\<25\> B\<24\> B\<23\> B\<22\> B\<21\> B\<20\> B\<19\> B\<18\> B\<17\> B\<16\> B\<15\> B\<14\> B\<13\> B\<12\> B\<11\> B\<10\> B\<9\> B\<8\> B\<7\> B\<6\> B\<5\> B\<4\> B\<3\> B\<2\> B\<1\> B\<0\> C\<31\> C\<30\> C\<29\> C\<28\> C\<27\> C\<26\> C\<25\> C\<24\> C\<23\> C\<22\> C\<21\> C\<20\> C\<19\> C\<18\> C\<17\> C\<16\> C\<15\> C\<14\> C\<13\> C\<12\> C\<11\> C\<10\> C\<9\> C\<8\> C\<7\> C\<6\> C\<5\> C\<4\> C\<3\> C\<2\> C\<1\> C\<0\>
    Thru31 (B\<0\> C\<0\>) iprobe
    Thru30 (B\<1\> C\<1\>) iprobe
    Thru29 (B\<2\> C\<2\>) iprobe
    Thru28 (B\<3\> C\<3\>) iprobe
    Thru27 (B\<4\> C\<4\>) iprobe
    Thru26 (B\<5\> C\<5\>) iprobe
    Thru25 (B\<6\> C\<6\>) iprobe
    Thru24 (B\<7\> C\<7\>) iprobe
    Thru23 (B\<8\> C\<8\>) iprobe
    Thru22 (B\<9\> C\<9\>) iprobe
    Thru21 (B\<10\> C\<10\>) iprobe
    Thru20 (B\<11\> C\<11\>) iprobe
    Thru19 (B\<12\> C\<12\>) iprobe
    Thru18 (B\<13\> C\<13\>) iprobe
    Thru17 (B\<14\> C\<14\>) iprobe
    Thru16 (B\<15\> C\<15\>) iprobe
    Thru15 (B\<16\> C\<16\>) iprobe
    Thru14 (B\<17\> C\<17\>) iprobe
    Thru13 (B\<18\> C\<18\>) iprobe
    Thru12 (B\<19\> C\<19\>) iprobe
    Thru11 (B\<20\> C\<20\>) iprobe
    Thru10 (B\<21\> C\<21\>) iprobe
    Thru9 (B\<22\> C\<22\>) iprobe
    Thru8 (B\<23\> C\<23\>) iprobe
    Thru7 (B\<24\> C\<24\>) iprobe
    Thru6 (B\<25\> C\<25\>) iprobe
    Thru5 (B\<26\> C\<26\>) iprobe
    Thru4 (B\<27\> C\<27\>) iprobe
    Thru3 (B\<28\> C\<28\>) iprobe
    Thru2 (B\<29\> C\<29\>) iprobe
    Thru1 (B\<30\> C\<30\>) iprobe
    Thru0 (B\<31\> C\<31\>) iprobe
ends alu_bpt

// power_gating_fine/alu_slt_DW01_cmp2_0/schematic
subckt alu_slt_DW01_cmp2_0 A\<31\> A\<30\> A\<29\> A\<28\> A\<27\> A\<26\> A\<25\> A\<24\> A\<23\> A\<22\> A\<21\> A\<20\> A\<19\> A\<18\> A\<17\> A\<16\> A\<15\> A\<14\> A\<13\> A\<12\> A\<11\> A\<10\> A\<9\> A\<8\> A\<7\> A\<6\> A\<5\> A\<4\> A\<3\> A\<2\> A\<1\> A\<0\> B\<31\> B\<30\> B\<29\> B\<28\> B\<27\> B\<26\> B\<25\> B\<24\> B\<23\> B\<22\> B\<21\> B\<20\> B\<19\> B\<18\> B\<17\> B\<16\> B\<15\> B\<14\> B\<13\> B\<12\> B\<11\> B\<10\> B\<9\> B\<8\> B\<7\> B\<6\> B\<5\> B\<4\> B\<3\> B\<2\> B\<1\> B\<0\> LEQ TC LT_LE GE_GT inh_gnd inh_gnds inh_vdd inh_vdds
    U3 (B\<31\> n3 inh_gnd inh_gnds inh_vdd inh_vdds) LVT_invx2_PB4_AFBB
    U36 (B\<31\> n36 inh_gnd inh_gnds inh_vdd inh_vdds) LVT_invx2_PB4_AFBB
    U5 (n66 n5 inh_gnd inh_gnds inh_vdd inh_vdds) LVT_invx2_PB4_AFBB
    U4 (B\<30\> n4 inh_gnd inh_gnds inh_vdd inh_vdds) LVT_invx2_PB4_AFBB
    U6 (n70 n6 inh_gnd inh_gnds inh_vdd inh_vdds) LVT_invx2_PB4_AFBB
    U37 (B\<30\> n37 inh_gnd inh_gnds inh_vdd inh_vdds) LVT_invx2_PB4_AFBB
    U7 (A\<29\> n7 inh_gnd inh_gnds inh_vdd inh_vdds) LVT_invx2_PB4_AFBB
    U38 (B\<29\> n38 inh_gnd inh_gnds inh_vdd inh_vdds) LVT_invx2_PB4_AFBB
    U8 (A\<28\> n8 inh_gnd inh_gnds inh_vdd inh_vdds) LVT_invx2_PB4_AFBB
    U39 (B\<28\> n39 inh_gnd inh_gnds inh_vdd inh_vdds) LVT_invx2_PB4_AFBB
    U9 (A\<27\> n9 inh_gnd inh_gnds inh_vdd inh_vdds) LVT_invx2_PB4_AFBB
    U40 (B\<27\> n40 inh_gnd inh_gnds inh_vdd inh_vdds) LVT_invx2_PB4_AFBB
    U10 (A\<26\> n10 inh_gnd inh_gnds inh_vdd inh_vdds) LVT_invx2_PB4_AFBB
    U41 (B\<26\> n41 inh_gnd inh_gnds inh_vdd inh_vdds) LVT_invx2_PB4_AFBB
    U11 (A\<25\> n11 inh_gnd inh_gnds inh_vdd inh_vdds) LVT_invx2_PB4_AFBB
    U42 (B\<25\> n42 inh_gnd inh_gnds inh_vdd inh_vdds) LVT_invx2_PB4_AFBB
    U12 (A\<24\> n12 inh_gnd inh_gnds inh_vdd inh_vdds) LVT_invx2_PB4_AFBB
    U43 (B\<24\> n43 inh_gnd inh_gnds inh_vdd inh_vdds) LVT_invx2_PB4_AFBB
    U13 (A\<23\> n13 inh_gnd inh_gnds inh_vdd inh_vdds) LVT_invx2_PB4_AFBB
    U44 (B\<23\> n44 inh_gnd inh_gnds inh_vdd inh_vdds) LVT_invx2_PB4_AFBB
    U14 (A\<22\> n14 inh_gnd inh_gnds inh_vdd inh_vdds) LVT_invx2_PB4_AFBB
    U45 (B\<22\> n45 inh_gnd inh_gnds inh_vdd inh_vdds) LVT_invx2_PB4_AFBB
    U15 (A\<21\> n15 inh_gnd inh_gnds inh_vdd inh_vdds) LVT_invx2_PB4_AFBB
    U46 (B\<21\> n46 inh_gnd inh_gnds inh_vdd inh_vdds) LVT_invx2_PB4_AFBB
    U16 (A\<20\> n16 inh_gnd inh_gnds inh_vdd inh_vdds) LVT_invx2_PB4_AFBB
    U47 (B\<20\> n47 inh_gnd inh_gnds inh_vdd inh_vdds) LVT_invx2_PB4_AFBB
    U17 (A\<19\> n17 inh_gnd inh_gnds inh_vdd inh_vdds) LVT_invx2_PB4_AFBB
    U48 (B\<19\> n48 inh_gnd inh_gnds inh_vdd inh_vdds) LVT_invx2_PB4_AFBB
    U18 (A\<18\> n18 inh_gnd inh_gnds inh_vdd inh_vdds) LVT_invx2_PB4_AFBB
    U49 (B\<18\> n49 inh_gnd inh_gnds inh_vdd inh_vdds) LVT_invx2_PB4_AFBB
    U19 (A\<17\> n19 inh_gnd inh_gnds inh_vdd inh_vdds) LVT_invx2_PB4_AFBB
    U50 (B\<17\> n50 inh_gnd inh_gnds inh_vdd inh_vdds) LVT_invx2_PB4_AFBB
    U20 (A\<16\> n20 inh_gnd inh_gnds inh_vdd inh_vdds) LVT_invx2_PB4_AFBB
    U51 (B\<16\> n51 inh_gnd inh_gnds inh_vdd inh_vdds) LVT_invx2_PB4_AFBB
    U21 (A\<15\> n21 inh_gnd inh_gnds inh_vdd inh_vdds) LVT_invx2_PB4_AFBB
    U52 (B\<15\> n52 inh_gnd inh_gnds inh_vdd inh_vdds) LVT_invx2_PB4_AFBB
    U22 (A\<14\> n22 inh_gnd inh_gnds inh_vdd inh_vdds) LVT_invx2_PB4_AFBB
    U53 (B\<14\> n53 inh_gnd inh_gnds inh_vdd inh_vdds) LVT_invx2_PB4_AFBB
    U23 (A\<13\> n23 inh_gnd inh_gnds inh_vdd inh_vdds) LVT_invx2_PB4_AFBB
    U54 (B\<13\> n54 inh_gnd inh_gnds inh_vdd inh_vdds) LVT_invx2_PB4_AFBB
    U24 (A\<12\> n24 inh_gnd inh_gnds inh_vdd inh_vdds) LVT_invx2_PB4_AFBB
    U55 (B\<12\> n55 inh_gnd inh_gnds inh_vdd inh_vdds) LVT_invx2_PB4_AFBB
    U25 (A\<11\> n25 inh_gnd inh_gnds inh_vdd inh_vdds) LVT_invx2_PB4_AFBB
    U56 (B\<11\> n56 inh_gnd inh_gnds inh_vdd inh_vdds) LVT_invx2_PB4_AFBB
    U26 (A\<10\> n26 inh_gnd inh_gnds inh_vdd inh_vdds) LVT_invx2_PB4_AFBB
    U57 (B\<9\> n57 inh_gnd inh_gnds inh_vdd inh_vdds) LVT_invx2_PB4_AFBB
    U1 (A\<10\> n1 inh_gnd inh_gnds inh_vdd inh_vdds) LVT_invx2_PB4_AFBB
    U2 (B\<9\> n2 inh_gnd inh_gnds inh_vdd inh_vdds) LVT_invx2_PB4_AFBB
    U27 (A\<8\> n27 inh_gnd inh_gnds inh_vdd inh_vdds) LVT_invx2_PB4_AFBB
    U58 (B\<8\> n58 inh_gnd inh_gnds inh_vdd inh_vdds) LVT_invx2_PB4_AFBB
    U28 (A\<7\> n28 inh_gnd inh_gnds inh_vdd inh_vdds) LVT_invx2_PB4_AFBB
    U59 (B\<7\> n59 inh_gnd inh_gnds inh_vdd inh_vdds) LVT_invx2_PB4_AFBB
    U29 (A\<6\> n29 inh_gnd inh_gnds inh_vdd inh_vdds) LVT_invx2_PB4_AFBB
    U60 (B\<6\> n60 inh_gnd inh_gnds inh_vdd inh_vdds) LVT_invx2_PB4_AFBB
    U30 (A\<5\> n30 inh_gnd inh_gnds inh_vdd inh_vdds) LVT_invx2_PB4_AFBB
    U61 (B\<5\> n61 inh_gnd inh_gnds inh_vdd inh_vdds) LVT_invx2_PB4_AFBB
    U31 (A\<4\> n31 inh_gnd inh_gnds inh_vdd inh_vdds) LVT_invx2_PB4_AFBB
    U62 (B\<4\> n62 inh_gnd inh_gnds inh_vdd inh_vdds) LVT_invx2_PB4_AFBB
    U32 (A\<3\> n32 inh_gnd inh_gnds inh_vdd inh_vdds) LVT_invx2_PB4_AFBB
    U63 (B\<3\> n63 inh_gnd inh_gnds inh_vdd inh_vdds) LVT_invx2_PB4_AFBB
    U33 (A\<2\> n33 inh_gnd inh_gnds inh_vdd inh_vdds) LVT_invx2_PB4_AFBB
    U64 (B\<2\> n64 inh_gnd inh_gnds inh_vdd inh_vdds) LVT_invx2_PB4_AFBB
    U34 (n186 n34 inh_gnd inh_gnds inh_vdd inh_vdds) LVT_invx2_PB4_AFBB
    U35 (A\<0\> n35 inh_gnd inh_gnds inh_vdd inh_vdds) LVT_invx2_PB4_AFBB
    U189 (A\<31\> n36 n65 inh_gnd inh_gnds inh_vdd inh_vdds) LVT_NADN2x1_PB4_AFBB
    U65 (n5 n65 LT_LE inh_gnd inh_gnds inh_vdd inh_vdds) LVT_NADN2x1_PB4_AFBB
    U70 (n72 n71 n70 inh_gnd inh_gnds inh_vdd inh_vdds) LVT_NADN2x1_PB4_AFBB
    U71 (A\<30\> n37 n72 inh_gnd inh_gnds inh_vdd inh_vdds) LVT_NADN2x1_PB4_AFBB
    U76 (B\<28\> n8 n78 inh_gnd inh_gnds inh_vdd inh_vdds) LVT_NADN2x1_PB4_AFBB
    U77 (n80 n79 n77 inh_gnd inh_gnds inh_vdd inh_vdds) LVT_NADN2x1_PB4_AFBB
    U78 (A\<28\> n39 n80 inh_gnd inh_gnds inh_vdd inh_vdds) LVT_NADN2x1_PB4_AFBB
    U75 (n77 n78 n76 inh_gnd inh_gnds inh_vdd inh_vdds) LVT_NADN2x1_PB4_AFBB
    U83 (B\<26\> n10 n86 inh_gnd inh_gnds inh_vdd inh_vdds) LVT_NADN2x1_PB4_AFBB
    U84 (n88 n87 n85 inh_gnd inh_gnds inh_vdd inh_vdds) LVT_NADN2x1_PB4_AFBB
    U85 (A\<26\> n41 n88 inh_gnd inh_gnds inh_vdd inh_vdds) LVT_NADN2x1_PB4_AFBB
    U82 (n85 n86 n84 inh_gnd inh_gnds inh_vdd inh_vdds) LVT_NADN2x1_PB4_AFBB
    U90 (B\<24\> n12 n94 inh_gnd inh_gnds inh_vdd inh_vdds) LVT_NADN2x1_PB4_AFBB
    U91 (n96 n95 n93 inh_gnd inh_gnds inh_vdd inh_vdds) LVT_NADN2x1_PB4_AFBB
    U92 (A\<24\> n43 n96 inh_gnd inh_gnds inh_vdd inh_vdds) LVT_NADN2x1_PB4_AFBB
    U89 (n93 n94 n92 inh_gnd inh_gnds inh_vdd inh_vdds) LVT_NADN2x1_PB4_AFBB
    U97 (B\<22\> n14 n102 inh_gnd inh_gnds inh_vdd inh_vdds) LVT_NADN2x1_PB4_AFBB
    U98 (n104 n103 n101 inh_gnd inh_gnds inh_vdd inh_vdds) LVT_NADN2x1_PB4_AFBB
    U99 (A\<22\> n45 n104 inh_gnd inh_gnds inh_vdd inh_vdds) LVT_NADN2x1_PB4_AFBB
    U96 (n101 n102 n100 inh_gnd inh_gnds inh_vdd inh_vdds) LVT_NADN2x1_PB4_AFBB
    U104 (B\<20\> n16 n110 inh_gnd inh_gnds inh_vdd inh_vdds) LVT_NADN2x1_PB4_AFBB
    U105 (n112 n111 n109 inh_gnd inh_gnds inh_vdd inh_vdds) LVT_NADN2x1_PB4_AFBB
    U106 (A\<20\> n47 n112 inh_gnd inh_gnds inh_vdd inh_vdds) LVT_NADN2x1_PB4_AFBB
    U103 (n109 n110 n108 inh_gnd inh_gnds inh_vdd inh_vdds) LVT_NADN2x1_PB4_AFBB
    U111 (B\<18\> n18 n118 inh_gnd inh_gnds inh_vdd inh_vdds) LVT_NADN2x1_PB4_AFBB
    U112 (n120 n119 n117 inh_gnd inh_gnds inh_vdd inh_vdds) LVT_NADN2x1_PB4_AFBB
    U113 (A\<18\> n49 n120 inh_gnd inh_gnds inh_vdd inh_vdds) LVT_NADN2x1_PB4_AFBB
    U110 (n117 n118 n116 inh_gnd inh_gnds inh_vdd inh_vdds) LVT_NADN2x1_PB4_AFBB
    U118 (B\<16\> n20 n126 inh_gnd inh_gnds inh_vdd inh_vdds) LVT_NADN2x1_PB4_AFBB
    U119 (n128 n127 n125 inh_gnd inh_gnds inh_vdd inh_vdds) LVT_NADN2x1_PB4_AFBB
    U120 (A\<16\> n51 n128 inh_gnd inh_gnds inh_vdd inh_vdds) LVT_NADN2x1_PB4_AFBB
    U117 (n125 n126 n124 inh_gnd inh_gnds inh_vdd inh_vdds) LVT_NADN2x1_PB4_AFBB
    U125 (B\<14\> n22 n134 inh_gnd inh_gnds inh_vdd inh_vdds) LVT_NADN2x1_PB4_AFBB
    U126 (n136 n135 n133 inh_gnd inh_gnds inh_vdd inh_vdds) LVT_NADN2x1_PB4_AFBB
    U127 (A\<14\> n53 n136 inh_gnd inh_gnds inh_vdd inh_vdds) LVT_NADN2x1_PB4_AFBB
    U124 (n133 n134 n132 inh_gnd inh_gnds inh_vdd inh_vdds) LVT_NADN2x1_PB4_AFBB
    U132 (B\<12\> n24 n142 inh_gnd inh_gnds inh_vdd inh_vdds) LVT_NADN2x1_PB4_AFBB
    U133 (n144 n143 n141 inh_gnd inh_gnds inh_vdd inh_vdds) LVT_NADN2x1_PB4_AFBB
    U134 (A\<12\> n55 n144 inh_gnd inh_gnds inh_vdd inh_vdds) LVT_NADN2x1_PB4_AFBB
    U131 (n141 n142 n140 inh_gnd inh_gnds inh_vdd inh_vdds) LVT_NADN2x1_PB4_AFBB
    U139 (B\<10\> n26 n150 inh_gnd inh_gnds inh_vdd inh_vdds) LVT_NADN2x1_PB4_AFBB
    U140 (n152 n151 n149 inh_gnd inh_gnds inh_vdd inh_vdds) LVT_NADN2x1_PB4_AFBB
    U141 (A\<9\> n57 n152 inh_gnd inh_gnds inh_vdd inh_vdds) LVT_NADN2x1_PB4_AFBB
    U138 (n149 n150 n148 inh_gnd inh_gnds inh_vdd inh_vdds) LVT_NADN2x1_PB4_AFBB
    U146 (B\<8\> n27 n158 inh_gnd inh_gnds inh_vdd inh_vdds) LVT_NADN2x1_PB4_AFBB
    U147 (n160 n159 n157 inh_gnd inh_gnds inh_vdd inh_vdds) LVT_NADN2x1_PB4_AFBB
    U148 (A\<8\> n58 n160 inh_gnd inh_gnds inh_vdd inh_vdds) LVT_NADN2x1_PB4_AFBB
    U145 (n157 n158 n156 inh_gnd inh_gnds inh_vdd inh_vdds) LVT_NADN2x1_PB4_AFBB
    U153 (B\<6\> n29 n166 inh_gnd inh_gnds inh_vdd inh_vdds) LVT_NADN2x1_PB4_AFBB
    U154 (n168 n167 n165 inh_gnd inh_gnds inh_vdd inh_vdds) LVT_NADN2x1_PB4_AFBB
    U155 (A\<6\> n60 n168 inh_gnd inh_gnds inh_vdd inh_vdds) LVT_NADN2x1_PB4_AFBB
    U152 (n165 n166 n164 inh_gnd inh_gnds inh_vdd inh_vdds) LVT_NADN2x1_PB4_AFBB
    U160 (B\<4\> n31 n174 inh_gnd inh_gnds inh_vdd inh_vdds) LVT_NADN2x1_PB4_AFBB
    U161 (n176 n175 n173 inh_gnd inh_gnds inh_vdd inh_vdds) LVT_NADN2x1_PB4_AFBB
    U162 (A\<4\> n62 n176 inh_gnd inh_gnds inh_vdd inh_vdds) LVT_NADN2x1_PB4_AFBB
    U159 (n173 n174 n172 inh_gnd inh_gnds inh_vdd inh_vdds) LVT_NADN2x1_PB4_AFBB
    U167 (B\<2\> n33 n182 inh_gnd inh_gnds inh_vdd inh_vdds) LVT_NADN2x1_PB4_AFBB
    U168 (n184 n183 n181 inh_gnd inh_gnds inh_vdd inh_vdds) LVT_NADN2x1_PB4_AFBB
    U169 (A\<2\> n64 n184 inh_gnd inh_gnds inh_vdd inh_vdds) LVT_NADN2x1_PB4_AFBB
    U166 (n181 n182 n180 inh_gnd inh_gnds inh_vdd inh_vdds) LVT_NADN2x1_PB4_AFBB
    U171 (A\<1\> n187 n186 inh_gnd inh_gnds inh_vdd inh_vdds) LVT_NADN2x1_PB4_AFBB
    U174 (B\<0\> n35 n187 inh_gnd inh_gnds inh_vdd inh_vdds) LVT_NADN2x1_PB4_AFBB
    U66 (n68 n67 n66 inh_gnd inh_gnds inh_vdd inh_vdds) LVT_NOR2x1_PB4_AFBB
    U67 (n3 A\<31\> n68 inh_gnd inh_gnds inh_vdd inh_vdds) LVT_NOR2x1_PB4_AFBB
    U69 (n4 A\<30\> n69 inh_gnd inh_gnds inh_vdd inh_vdds) LVT_NOR2x1_PB4_AFBB
    U68 (n69 n6 n67 inh_gnd inh_gnds inh_vdd inh_vdds) LVT_NOR2x1_PB4_AFBB
    U73 (B\<29\> n7 n74 inh_gnd inh_gnds inh_vdd inh_vdds) LVT_NOR2x1_PB4_AFBB
    U74 (n76 n75 n73 inh_gnd inh_gnds inh_vdd inh_vdds) LVT_NOR2x1_PB4_AFBB
    U188 (A\<29\> n38 n75 inh_gnd inh_gnds inh_vdd inh_vdds) LVT_NOR2x1_PB4_AFBB
    U72 (n74 n73 n71 inh_gnd inh_gnds inh_vdd inh_vdds) LVT_NOR2x1_PB4_AFBB
    U80 (B\<27\> n9 n82 inh_gnd inh_gnds inh_vdd inh_vdds) LVT_NOR2x1_PB4_AFBB
    U81 (n84 n83 n81 inh_gnd inh_gnds inh_vdd inh_vdds) LVT_NOR2x1_PB4_AFBB
    U187 (A\<27\> n40 n83 inh_gnd inh_gnds inh_vdd inh_vdds) LVT_NOR2x1_PB4_AFBB
    U79 (n82 n81 n79 inh_gnd inh_gnds inh_vdd inh_vdds) LVT_NOR2x1_PB4_AFBB
    U87 (B\<25\> n11 n90 inh_gnd inh_gnds inh_vdd inh_vdds) LVT_NOR2x1_PB4_AFBB
    U88 (n92 n91 n89 inh_gnd inh_gnds inh_vdd inh_vdds) LVT_NOR2x1_PB4_AFBB
    U186 (A\<25\> n42 n91 inh_gnd inh_gnds inh_vdd inh_vdds) LVT_NOR2x1_PB4_AFBB
    U86 (n90 n89 n87 inh_gnd inh_gnds inh_vdd inh_vdds) LVT_NOR2x1_PB4_AFBB
    U94 (B\<23\> n13 n98 inh_gnd inh_gnds inh_vdd inh_vdds) LVT_NOR2x1_PB4_AFBB
    U95 (n100 n99 n97 inh_gnd inh_gnds inh_vdd inh_vdds) LVT_NOR2x1_PB4_AFBB
    U185 (A\<23\> n44 n99 inh_gnd inh_gnds inh_vdd inh_vdds) LVT_NOR2x1_PB4_AFBB
    U93 (n98 n97 n95 inh_gnd inh_gnds inh_vdd inh_vdds) LVT_NOR2x1_PB4_AFBB
    U101 (B\<21\> n15 n106 inh_gnd inh_gnds inh_vdd inh_vdds) LVT_NOR2x1_PB4_AFBB
    U102 (n108 n107 n105 inh_gnd inh_gnds inh_vdd inh_vdds) LVT_NOR2x1_PB4_AFBB
    U184 (A\<21\> n46 n107 inh_gnd inh_gnds inh_vdd inh_vdds) LVT_NOR2x1_PB4_AFBB
    U100 (n106 n105 n103 inh_gnd inh_gnds inh_vdd inh_vdds) LVT_NOR2x1_PB4_AFBB
    U108 (B\<19\> n17 n114 inh_gnd inh_gnds inh_vdd inh_vdds) LVT_NOR2x1_PB4_AFBB
    U109 (n116 n115 n113 inh_gnd inh_gnds inh_vdd inh_vdds) LVT_NOR2x1_PB4_AFBB
    U183 (A\<19\> n48 n115 inh_gnd inh_gnds inh_vdd inh_vdds) LVT_NOR2x1_PB4_AFBB
    U107 (n114 n113 n111 inh_gnd inh_gnds inh_vdd inh_vdds) LVT_NOR2x1_PB4_AFBB
    U115 (B\<17\> n19 n122 inh_gnd inh_gnds inh_vdd inh_vdds) LVT_NOR2x1_PB4_AFBB
    U116 (n124 n123 n121 inh_gnd inh_gnds inh_vdd inh_vdds) LVT_NOR2x1_PB4_AFBB
    U182 (A\<17\> n50 n123 inh_gnd inh_gnds inh_vdd inh_vdds) LVT_NOR2x1_PB4_AFBB
    U114 (n122 n121 n119 inh_gnd inh_gnds inh_vdd inh_vdds) LVT_NOR2x1_PB4_AFBB
    U122 (B\<15\> n21 n130 inh_gnd inh_gnds inh_vdd inh_vdds) LVT_NOR2x1_PB4_AFBB
    U123 (n132 n131 n129 inh_gnd inh_gnds inh_vdd inh_vdds) LVT_NOR2x1_PB4_AFBB
    U181 (A\<15\> n52 n131 inh_gnd inh_gnds inh_vdd inh_vdds) LVT_NOR2x1_PB4_AFBB
    U121 (n130 n129 n127 inh_gnd inh_gnds inh_vdd inh_vdds) LVT_NOR2x1_PB4_AFBB
    U129 (B\<13\> n23 n138 inh_gnd inh_gnds inh_vdd inh_vdds) LVT_NOR2x1_PB4_AFBB
    U130 (n140 n139 n137 inh_gnd inh_gnds inh_vdd inh_vdds) LVT_NOR2x1_PB4_AFBB
    U180 (A\<13\> n54 n139 inh_gnd inh_gnds inh_vdd inh_vdds) LVT_NOR2x1_PB4_AFBB
    U128 (n138 n137 n135 inh_gnd inh_gnds inh_vdd inh_vdds) LVT_NOR2x1_PB4_AFBB
    U136 (B\<11\> n25 n146 inh_gnd inh_gnds inh_vdd inh_vdds) LVT_NOR2x1_PB4_AFBB
    U137 (n148 n147 n145 inh_gnd inh_gnds inh_vdd inh_vdds) LVT_NOR2x1_PB4_AFBB
    U179 (A\<11\> n56 n147 inh_gnd inh_gnds inh_vdd inh_vdds) LVT_NOR2x1_PB4_AFBB
    U135 (n146 n145 n143 inh_gnd inh_gnds inh_vdd inh_vdds) LVT_NOR2x1_PB4_AFBB
    U144 (n156 n155 n153 inh_gnd inh_gnds inh_vdd inh_vdds) LVT_NOR2x1_PB4_AFBB
    U142 (n154 n153 n151 inh_gnd inh_gnds inh_vdd inh_vdds) LVT_NOR2x1_PB4_AFBB
    U143 (B\<10\> n1 n154 inh_gnd inh_gnds inh_vdd inh_vdds) LVT_NOR2x1_PB4_AFBB
    U178 (A\<9\> n2 n155 inh_gnd inh_gnds inh_vdd inh_vdds) LVT_NOR2x1_PB4_AFBB
    U150 (B\<7\> n28 n162 inh_gnd inh_gnds inh_vdd inh_vdds) LVT_NOR2x1_PB4_AFBB
    U151 (n164 n163 n161 inh_gnd inh_gnds inh_vdd inh_vdds) LVT_NOR2x1_PB4_AFBB
    U177 (A\<7\> n59 n163 inh_gnd inh_gnds inh_vdd inh_vdds) LVT_NOR2x1_PB4_AFBB
    U149 (n162 n161 n159 inh_gnd inh_gnds inh_vdd inh_vdds) LVT_NOR2x1_PB4_AFBB
    U157 (B\<5\> n30 n170 inh_gnd inh_gnds inh_vdd inh_vdds) LVT_NOR2x1_PB4_AFBB
    U158 (n172 n171 n169 inh_gnd inh_gnds inh_vdd inh_vdds) LVT_NOR2x1_PB4_AFBB
    U176 (A\<5\> n61 n171 inh_gnd inh_gnds inh_vdd inh_vdds) LVT_NOR2x1_PB4_AFBB
    U156 (n170 n169 n167 inh_gnd inh_gnds inh_vdd inh_vdds) LVT_NOR2x1_PB4_AFBB
    U164 (B\<3\> n32 n178 inh_gnd inh_gnds inh_vdd inh_vdds) LVT_NOR2x1_PB4_AFBB
    U165 (n180 n179 n177 inh_gnd inh_gnds inh_vdd inh_vdds) LVT_NOR2x1_PB4_AFBB
    U175 (A\<3\> n63 n179 inh_gnd inh_gnds inh_vdd inh_vdds) LVT_NOR2x1_PB4_AFBB
    U163 (n178 n177 n175 inh_gnd inh_gnds inh_vdd inh_vdds) LVT_NOR2x1_PB4_AFBB
    U172 (B\<1\> n188 n185 inh_gnd inh_gnds inh_vdd inh_vdds) LVT_NOR2x1_PB4_AFBB
    U173 (A\<1\> n187 n188 inh_gnd inh_gnds inh_vdd inh_vdds) LVT_NOR2x1_PB4_AFBB
    U170 (n185 n34 n183 inh_gnd inh_gnds inh_vdd inh_vdds) LVT_NOR2x1_PB4_AFBB
ends alu_slt_DW01_cmp2_0

// power_gating_fine/alu_slt/schematic
subckt alu_slt pwr_en A\<31\> A\<30\> A\<29\> A\<28\> A\<27\> A\<26\> A\<25\> A\<24\> A\<23\> A\<22\> A\<21\> A\<20\> A\<19\> A\<18\> A\<17\> A\<16\> A\<15\> A\<14\> A\<13\> A\<12\> A\<11\> A\<10\> A\<9\> A\<8\> A\<7\> A\<6\> A\<5\> A\<4\> A\<3\> A\<2\> A\<1\> A\<0\> B\<31\> B\<30\> B\<29\> B\<28\> B\<27\> B\<26\> B\<25\> B\<24\> B\<23\> B\<22\> B\<21\> B\<20\> B\<19\> B\<18\> B\<17\> B\<16\> B\<15\> B\<14\> B\<13\> B\<12\> B\<11\> B\<10\> B\<9\> B\<8\> B\<7\> B\<6\> B\<5\> B\<4\> B\<3\> B\<2\> B\<1\> B\<0\> C\<31\> C\<30\> C\<29\> C\<28\> C\<27\> C\<26\> C\<25\> C\<24\> C\<23\> C\<22\> C\<21\> C\<20\> C\<19\> C\<18\> C\<17\> C\<16\> C\<15\> C\<14\> C\<13\> C\<12\> C\<11\> C\<10\> C\<9\> C\<8\> C\<7\> C\<6\> C\<5\> C\<4\> C\<3\> C\<2\> C\<1\> C\<0\> inh_gnd inh_gnds vdd_in inh_vdds
    UG160 (pwr_en pwr_en_bar inh_gnd inh_gnds vdd_in inh_vdds) LVT_invx2_PB4_AFBB
    alu_slt_pwr_pmos (inh_vdd pwr_en_bar vdd_in inh_vdds) lvtpfet w=8000n l=30.00n nf=(2)*(1) ngcon=1 nsig_delvto_uo1=0 nsig_delvto_uo2=0 soa=1 swshe=0 swacc=0 swrg=0 swrsub=0 mismatch=1 m=1
    Thru0 (N32 C\<0\>) iprobe
    Thru31 (GND! C\<31\>) iprobe
    Thru30 (GND! C\<30\>) iprobe
    Thru29 (GND! C\<29\>) iprobe
    Thru28 (GND! C\<28\>) iprobe
    Thru27 (GND! C\<27\>) iprobe
    Thru26 (GND! C\<26\>) iprobe
    Thru25 (GND! C\<25\>) iprobe
    Thru24 (GND! C\<24\>) iprobe
    Thru23 (GND! C\<23\>) iprobe
    Thru22 (GND! C\<22\>) iprobe
    Thru21 (GND! C\<21\>) iprobe
    Thru20 (GND! C\<20\>) iprobe
    Thru19 (GND! C\<19\>) iprobe
    Thru18 (GND! C\<18\>) iprobe
    Thru17 (GND! C\<17\>) iprobe
    Thru16 (GND! C\<16\>) iprobe
    Thru15 (GND! C\<15\>) iprobe
    Thru14 (GND! C\<14\>) iprobe
    Thru13 (GND! C\<13\>) iprobe
    Thru12 (GND! C\<12\>) iprobe
    Thru11 (GND! C\<11\>) iprobe
    Thru10 (GND! C\<10\>) iprobe
    Thru9 (GND! C\<9\>) iprobe
    Thru8 (GND! C\<8\>) iprobe
    Thru7 (GND! C\<7\>) iprobe
    Thru6 (GND! C\<6\>) iprobe
    Thru5 (GND! C\<5\>) iprobe
    Thru4 (GND! C\<4\>) iprobe
    Thru3 (GND! C\<3\>) iprobe
    Thru2 (GND! C\<2\>) iprobe
    Thru1 (GND! C\<1\>) iprobe
    lt_24 (A\<31\> A\<30\> A\<29\> A\<28\> A\<27\> A\<26\> A\<25\> A\<24\> A\<23\> A\<22\> A\<21\> A\<20\> A\<19\> A\<18\> A\<17\> A\<16\> A\<15\> A\<14\> A\<13\> A\<12\> A\<11\> A\<10\> A\<9\> A\<8\> A\<7\> A\<6\> A\<5\> A\<4\> A\<3\> A\<2\> A\<1\> A\<0\> B\<31\> B\<30\> B\<29\> B\<28\> B\<27\> B\<26\> B\<25\> B\<24\> B\<23\> B\<22\> B\<21\> B\<20\> B\<19\> B\<18\> B\<17\> B\<16\> B\<15\> B\<14\> B\<13\> B\<12\> B\<11\> B\<10\> B\<9\> B\<8\> B\<7\> B\<6\> B\<5\> B\<4\> B\<3\> B\<2\> B\<1\> B\<0\> GND! VDD! N32 NeTt_109 inh_gnd inh_gnds inh_vdd inh_vdds) alu_slt_DW01_cmp2_0
ends alu_slt

// power_gating_fine/alu_sltu_DW01_cmp2_0/schematic
subckt alu_sltu_DW01_cmp2_0 A\<31\> A\<30\> A\<29\> A\<28\> A\<27\> A\<26\> A\<25\> A\<24\> A\<23\> A\<22\> A\<21\> A\<20\> A\<19\> A\<18\> A\<17\> A\<16\> A\<15\> A\<14\> A\<13\> A\<12\> A\<11\> A\<10\> A\<9\> A\<8\> A\<7\> A\<6\> A\<5\> A\<4\> A\<3\> A\<2\> A\<1\> A\<0\> B\<31\> B\<30\> B\<29\> B\<28\> B\<27\> B\<26\> B\<25\> B\<24\> B\<23\> B\<22\> B\<21\> B\<20\> B\<19\> B\<18\> B\<17\> B\<16\> B\<15\> B\<14\> B\<13\> B\<12\> B\<11\> B\<10\> B\<9\> B\<8\> B\<7\> B\<6\> B\<5\> B\<4\> B\<3\> B\<2\> B\<1\> B\<0\> LEQ TC LT_LE GE_GT inh_gnd inh_gnds inh_vdd inh_vdds
    U3 (A\<31\> n3 inh_gnd inh_gnds inh_vdd inh_vdds) LVT_invx2_PB4_AFBB
    U6 (A\<31\> n6 inh_gnd inh_gnds inh_vdd inh_vdds) LVT_invx2_PB4_AFBB
    U5 (n66 n5 inh_gnd inh_gnds inh_vdd inh_vdds) LVT_invx2_PB4_AFBB
    U4 (B\<30\> n4 inh_gnd inh_gnds inh_vdd inh_vdds) LVT_invx2_PB4_AFBB
    U7 (n70 n7 inh_gnd inh_gnds inh_vdd inh_vdds) LVT_invx2_PB4_AFBB
    U37 (B\<30\> n37 inh_gnd inh_gnds inh_vdd inh_vdds) LVT_invx2_PB4_AFBB
    U8 (A\<29\> n8 inh_gnd inh_gnds inh_vdd inh_vdds) LVT_invx2_PB4_AFBB
    U38 (B\<29\> n38 inh_gnd inh_gnds inh_vdd inh_vdds) LVT_invx2_PB4_AFBB
    U9 (A\<28\> n9 inh_gnd inh_gnds inh_vdd inh_vdds) LVT_invx2_PB4_AFBB
    U39 (B\<28\> n39 inh_gnd inh_gnds inh_vdd inh_vdds) LVT_invx2_PB4_AFBB
    U10 (A\<27\> n10 inh_gnd inh_gnds inh_vdd inh_vdds) LVT_invx2_PB4_AFBB
    U40 (B\<27\> n40 inh_gnd inh_gnds inh_vdd inh_vdds) LVT_invx2_PB4_AFBB
    U11 (A\<26\> n11 inh_gnd inh_gnds inh_vdd inh_vdds) LVT_invx2_PB4_AFBB
    U41 (B\<26\> n41 inh_gnd inh_gnds inh_vdd inh_vdds) LVT_invx2_PB4_AFBB
    U12 (A\<25\> n12 inh_gnd inh_gnds inh_vdd inh_vdds) LVT_invx2_PB4_AFBB
    U42 (B\<25\> n42 inh_gnd inh_gnds inh_vdd inh_vdds) LVT_invx2_PB4_AFBB
    U13 (A\<24\> n13 inh_gnd inh_gnds inh_vdd inh_vdds) LVT_invx2_PB4_AFBB
    U43 (B\<24\> n43 inh_gnd inh_gnds inh_vdd inh_vdds) LVT_invx2_PB4_AFBB
    U14 (A\<23\> n14 inh_gnd inh_gnds inh_vdd inh_vdds) LVT_invx2_PB4_AFBB
    U44 (B\<23\> n44 inh_gnd inh_gnds inh_vdd inh_vdds) LVT_invx2_PB4_AFBB
    U15 (A\<22\> n15 inh_gnd inh_gnds inh_vdd inh_vdds) LVT_invx2_PB4_AFBB
    U45 (B\<22\> n45 inh_gnd inh_gnds inh_vdd inh_vdds) LVT_invx2_PB4_AFBB
    U16 (A\<21\> n16 inh_gnd inh_gnds inh_vdd inh_vdds) LVT_invx2_PB4_AFBB
    U46 (B\<21\> n46 inh_gnd inh_gnds inh_vdd inh_vdds) LVT_invx2_PB4_AFBB
    U17 (A\<20\> n17 inh_gnd inh_gnds inh_vdd inh_vdds) LVT_invx2_PB4_AFBB
    U47 (B\<20\> n47 inh_gnd inh_gnds inh_vdd inh_vdds) LVT_invx2_PB4_AFBB
    U18 (A\<19\> n18 inh_gnd inh_gnds inh_vdd inh_vdds) LVT_invx2_PB4_AFBB
    U48 (B\<19\> n48 inh_gnd inh_gnds inh_vdd inh_vdds) LVT_invx2_PB4_AFBB
    U19 (A\<18\> n19 inh_gnd inh_gnds inh_vdd inh_vdds) LVT_invx2_PB4_AFBB
    U49 (B\<18\> n49 inh_gnd inh_gnds inh_vdd inh_vdds) LVT_invx2_PB4_AFBB
    U20 (A\<17\> n20 inh_gnd inh_gnds inh_vdd inh_vdds) LVT_invx2_PB4_AFBB
    U50 (B\<17\> n50 inh_gnd inh_gnds inh_vdd inh_vdds) LVT_invx2_PB4_AFBB
    U21 (A\<16\> n21 inh_gnd inh_gnds inh_vdd inh_vdds) LVT_invx2_PB4_AFBB
    U51 (B\<16\> n51 inh_gnd inh_gnds inh_vdd inh_vdds) LVT_invx2_PB4_AFBB
    U22 (A\<15\> n22 inh_gnd inh_gnds inh_vdd inh_vdds) LVT_invx2_PB4_AFBB
    U52 (B\<15\> n52 inh_gnd inh_gnds inh_vdd inh_vdds) LVT_invx2_PB4_AFBB
    U23 (A\<14\> n23 inh_gnd inh_gnds inh_vdd inh_vdds) LVT_invx2_PB4_AFBB
    U53 (B\<14\> n53 inh_gnd inh_gnds inh_vdd inh_vdds) LVT_invx2_PB4_AFBB
    U24 (A\<13\> n24 inh_gnd inh_gnds inh_vdd inh_vdds) LVT_invx2_PB4_AFBB
    U54 (B\<13\> n54 inh_gnd inh_gnds inh_vdd inh_vdds) LVT_invx2_PB4_AFBB
    U25 (A\<12\> n25 inh_gnd inh_gnds inh_vdd inh_vdds) LVT_invx2_PB4_AFBB
    U55 (B\<12\> n55 inh_gnd inh_gnds inh_vdd inh_vdds) LVT_invx2_PB4_AFBB
    U26 (A\<11\> n26 inh_gnd inh_gnds inh_vdd inh_vdds) LVT_invx2_PB4_AFBB
    U56 (B\<11\> n56 inh_gnd inh_gnds inh_vdd inh_vdds) LVT_invx2_PB4_AFBB
    U27 (A\<10\> n27 inh_gnd inh_gnds inh_vdd inh_vdds) LVT_invx2_PB4_AFBB
    U57 (B\<9\> n57 inh_gnd inh_gnds inh_vdd inh_vdds) LVT_invx2_PB4_AFBB
    U1 (A\<10\> n1 inh_gnd inh_gnds inh_vdd inh_vdds) LVT_invx2_PB4_AFBB
    U2 (B\<9\> n2 inh_gnd inh_gnds inh_vdd inh_vdds) LVT_invx2_PB4_AFBB
    U28 (A\<8\> n28 inh_gnd inh_gnds inh_vdd inh_vdds) LVT_invx2_PB4_AFBB
    U58 (B\<8\> n58 inh_gnd inh_gnds inh_vdd inh_vdds) LVT_invx2_PB4_AFBB
    U29 (A\<7\> n29 inh_gnd inh_gnds inh_vdd inh_vdds) LVT_invx2_PB4_AFBB
    U59 (B\<7\> n59 inh_gnd inh_gnds inh_vdd inh_vdds) LVT_invx2_PB4_AFBB
    U30 (A\<6\> n30 inh_gnd inh_gnds inh_vdd inh_vdds) LVT_invx2_PB4_AFBB
    U60 (B\<6\> n60 inh_gnd inh_gnds inh_vdd inh_vdds) LVT_invx2_PB4_AFBB
    U31 (A\<5\> n31 inh_gnd inh_gnds inh_vdd inh_vdds) LVT_invx2_PB4_AFBB
    U61 (B\<5\> n61 inh_gnd inh_gnds inh_vdd inh_vdds) LVT_invx2_PB4_AFBB
    U32 (A\<4\> n32 inh_gnd inh_gnds inh_vdd inh_vdds) LVT_invx2_PB4_AFBB
    U62 (B\<4\> n62 inh_gnd inh_gnds inh_vdd inh_vdds) LVT_invx2_PB4_AFBB
    U33 (A\<3\> n33 inh_gnd inh_gnds inh_vdd inh_vdds) LVT_invx2_PB4_AFBB
    U63 (B\<3\> n63 inh_gnd inh_gnds inh_vdd inh_vdds) LVT_invx2_PB4_AFBB
    U34 (A\<2\> n34 inh_gnd inh_gnds inh_vdd inh_vdds) LVT_invx2_PB4_AFBB
    U64 (B\<2\> n64 inh_gnd inh_gnds inh_vdd inh_vdds) LVT_invx2_PB4_AFBB
    U35 (n186 n35 inh_gnd inh_gnds inh_vdd inh_vdds) LVT_invx2_PB4_AFBB
    U36 (A\<0\> n36 inh_gnd inh_gnds inh_vdd inh_vdds) LVT_invx2_PB4_AFBB
    U189 (B\<31\> n6 n65 inh_gnd inh_gnds inh_vdd inh_vdds) LVT_NADN2x1_PB4_AFBB
    U65 (n5 n65 LT_LE inh_gnd inh_gnds inh_vdd inh_vdds) LVT_NADN2x1_PB4_AFBB
    U70 (n72 n71 n70 inh_gnd inh_gnds inh_vdd inh_vdds) LVT_NADN2x1_PB4_AFBB
    U71 (A\<30\> n37 n72 inh_gnd inh_gnds inh_vdd inh_vdds) LVT_NADN2x1_PB4_AFBB
    U76 (B\<28\> n9 n78 inh_gnd inh_gnds inh_vdd inh_vdds) LVT_NADN2x1_PB4_AFBB
    U77 (n80 n79 n77 inh_gnd inh_gnds inh_vdd inh_vdds) LVT_NADN2x1_PB4_AFBB
    U78 (A\<28\> n39 n80 inh_gnd inh_gnds inh_vdd inh_vdds) LVT_NADN2x1_PB4_AFBB
    U75 (n77 n78 n76 inh_gnd inh_gnds inh_vdd inh_vdds) LVT_NADN2x1_PB4_AFBB
    U83 (B\<26\> n11 n86 inh_gnd inh_gnds inh_vdd inh_vdds) LVT_NADN2x1_PB4_AFBB
    U84 (n88 n87 n85 inh_gnd inh_gnds inh_vdd inh_vdds) LVT_NADN2x1_PB4_AFBB
    U85 (A\<26\> n41 n88 inh_gnd inh_gnds inh_vdd inh_vdds) LVT_NADN2x1_PB4_AFBB
    U82 (n85 n86 n84 inh_gnd inh_gnds inh_vdd inh_vdds) LVT_NADN2x1_PB4_AFBB
    U90 (B\<24\> n13 n94 inh_gnd inh_gnds inh_vdd inh_vdds) LVT_NADN2x1_PB4_AFBB
    U91 (n96 n95 n93 inh_gnd inh_gnds inh_vdd inh_vdds) LVT_NADN2x1_PB4_AFBB
    U92 (A\<24\> n43 n96 inh_gnd inh_gnds inh_vdd inh_vdds) LVT_NADN2x1_PB4_AFBB
    U89 (n93 n94 n92 inh_gnd inh_gnds inh_vdd inh_vdds) LVT_NADN2x1_PB4_AFBB
    U97 (B\<22\> n15 n102 inh_gnd inh_gnds inh_vdd inh_vdds) LVT_NADN2x1_PB4_AFBB
    U98 (n104 n103 n101 inh_gnd inh_gnds inh_vdd inh_vdds) LVT_NADN2x1_PB4_AFBB
    U99 (A\<22\> n45 n104 inh_gnd inh_gnds inh_vdd inh_vdds) LVT_NADN2x1_PB4_AFBB
    U96 (n101 n102 n100 inh_gnd inh_gnds inh_vdd inh_vdds) LVT_NADN2x1_PB4_AFBB
    U104 (B\<20\> n17 n110 inh_gnd inh_gnds inh_vdd inh_vdds) LVT_NADN2x1_PB4_AFBB
    U105 (n112 n111 n109 inh_gnd inh_gnds inh_vdd inh_vdds) LVT_NADN2x1_PB4_AFBB
    U106 (A\<20\> n47 n112 inh_gnd inh_gnds inh_vdd inh_vdds) LVT_NADN2x1_PB4_AFBB
    U103 (n109 n110 n108 inh_gnd inh_gnds inh_vdd inh_vdds) LVT_NADN2x1_PB4_AFBB
    U111 (B\<18\> n19 n118 inh_gnd inh_gnds inh_vdd inh_vdds) LVT_NADN2x1_PB4_AFBB
    U112 (n120 n119 n117 inh_gnd inh_gnds inh_vdd inh_vdds) LVT_NADN2x1_PB4_AFBB
    U113 (A\<18\> n49 n120 inh_gnd inh_gnds inh_vdd inh_vdds) LVT_NADN2x1_PB4_AFBB
    U110 (n117 n118 n116 inh_gnd inh_gnds inh_vdd inh_vdds) LVT_NADN2x1_PB4_AFBB
    U118 (B\<16\> n21 n126 inh_gnd inh_gnds inh_vdd inh_vdds) LVT_NADN2x1_PB4_AFBB
    U119 (n128 n127 n125 inh_gnd inh_gnds inh_vdd inh_vdds) LVT_NADN2x1_PB4_AFBB
    U120 (A\<16\> n51 n128 inh_gnd inh_gnds inh_vdd inh_vdds) LVT_NADN2x1_PB4_AFBB
    U117 (n125 n126 n124 inh_gnd inh_gnds inh_vdd inh_vdds) LVT_NADN2x1_PB4_AFBB
    U125 (B\<14\> n23 n134 inh_gnd inh_gnds inh_vdd inh_vdds) LVT_NADN2x1_PB4_AFBB
    U126 (n136 n135 n133 inh_gnd inh_gnds inh_vdd inh_vdds) LVT_NADN2x1_PB4_AFBB
    U127 (A\<14\> n53 n136 inh_gnd inh_gnds inh_vdd inh_vdds) LVT_NADN2x1_PB4_AFBB
    U124 (n133 n134 n132 inh_gnd inh_gnds inh_vdd inh_vdds) LVT_NADN2x1_PB4_AFBB
    U132 (B\<12\> n25 n142 inh_gnd inh_gnds inh_vdd inh_vdds) LVT_NADN2x1_PB4_AFBB
    U133 (n144 n143 n141 inh_gnd inh_gnds inh_vdd inh_vdds) LVT_NADN2x1_PB4_AFBB
    U134 (A\<12\> n55 n144 inh_gnd inh_gnds inh_vdd inh_vdds) LVT_NADN2x1_PB4_AFBB
    U131 (n141 n142 n140 inh_gnd inh_gnds inh_vdd inh_vdds) LVT_NADN2x1_PB4_AFBB
    U139 (B\<10\> n27 n150 inh_gnd inh_gnds inh_vdd inh_vdds) LVT_NADN2x1_PB4_AFBB
    U140 (n152 n151 n149 inh_gnd inh_gnds inh_vdd inh_vdds) LVT_NADN2x1_PB4_AFBB
    U141 (A\<9\> n57 n152 inh_gnd inh_gnds inh_vdd inh_vdds) LVT_NADN2x1_PB4_AFBB
    U138 (n149 n150 n148 inh_gnd inh_gnds inh_vdd inh_vdds) LVT_NADN2x1_PB4_AFBB
    U146 (B\<8\> n28 n158 inh_gnd inh_gnds inh_vdd inh_vdds) LVT_NADN2x1_PB4_AFBB
    U147 (n160 n159 n157 inh_gnd inh_gnds inh_vdd inh_vdds) LVT_NADN2x1_PB4_AFBB
    U148 (A\<8\> n58 n160 inh_gnd inh_gnds inh_vdd inh_vdds) LVT_NADN2x1_PB4_AFBB
    U145 (n157 n158 n156 inh_gnd inh_gnds inh_vdd inh_vdds) LVT_NADN2x1_PB4_AFBB
    U153 (B\<6\> n30 n166 inh_gnd inh_gnds inh_vdd inh_vdds) LVT_NADN2x1_PB4_AFBB
    U154 (n168 n167 n165 inh_gnd inh_gnds inh_vdd inh_vdds) LVT_NADN2x1_PB4_AFBB
    U155 (A\<6\> n60 n168 inh_gnd inh_gnds inh_vdd inh_vdds) LVT_NADN2x1_PB4_AFBB
    U152 (n165 n166 n164 inh_gnd inh_gnds inh_vdd inh_vdds) LVT_NADN2x1_PB4_AFBB
    U160 (B\<4\> n32 n174 inh_gnd inh_gnds inh_vdd inh_vdds) LVT_NADN2x1_PB4_AFBB
    U161 (n176 n175 n173 inh_gnd inh_gnds inh_vdd inh_vdds) LVT_NADN2x1_PB4_AFBB
    U162 (A\<4\> n62 n176 inh_gnd inh_gnds inh_vdd inh_vdds) LVT_NADN2x1_PB4_AFBB
    U159 (n173 n174 n172 inh_gnd inh_gnds inh_vdd inh_vdds) LVT_NADN2x1_PB4_AFBB
    U167 (B\<2\> n34 n182 inh_gnd inh_gnds inh_vdd inh_vdds) LVT_NADN2x1_PB4_AFBB
    U168 (n184 n183 n181 inh_gnd inh_gnds inh_vdd inh_vdds) LVT_NADN2x1_PB4_AFBB
    U169 (A\<2\> n64 n184 inh_gnd inh_gnds inh_vdd inh_vdds) LVT_NADN2x1_PB4_AFBB
    U166 (n181 n182 n180 inh_gnd inh_gnds inh_vdd inh_vdds) LVT_NADN2x1_PB4_AFBB
    U171 (A\<1\> n187 n186 inh_gnd inh_gnds inh_vdd inh_vdds) LVT_NADN2x1_PB4_AFBB
    U174 (B\<0\> n36 n187 inh_gnd inh_gnds inh_vdd inh_vdds) LVT_NADN2x1_PB4_AFBB
    U66 (n68 n67 n66 inh_gnd inh_gnds inh_vdd inh_vdds) LVT_NOR2x1_PB4_AFBB
    U67 (n3 B\<31\> n68 inh_gnd inh_gnds inh_vdd inh_vdds) LVT_NOR2x1_PB4_AFBB
    U69 (n4 A\<30\> n69 inh_gnd inh_gnds inh_vdd inh_vdds) LVT_NOR2x1_PB4_AFBB
    U68 (n69 n7 n67 inh_gnd inh_gnds inh_vdd inh_vdds) LVT_NOR2x1_PB4_AFBB
    U73 (B\<29\> n8 n74 inh_gnd inh_gnds inh_vdd inh_vdds) LVT_NOR2x1_PB4_AFBB
    U74 (n76 n75 n73 inh_gnd inh_gnds inh_vdd inh_vdds) LVT_NOR2x1_PB4_AFBB
    U188 (A\<29\> n38 n75 inh_gnd inh_gnds inh_vdd inh_vdds) LVT_NOR2x1_PB4_AFBB
    U72 (n74 n73 n71 inh_gnd inh_gnds inh_vdd inh_vdds) LVT_NOR2x1_PB4_AFBB
    U80 (B\<27\> n10 n82 inh_gnd inh_gnds inh_vdd inh_vdds) LVT_NOR2x1_PB4_AFBB
    U81 (n84 n83 n81 inh_gnd inh_gnds inh_vdd inh_vdds) LVT_NOR2x1_PB4_AFBB
    U187 (A\<27\> n40 n83 inh_gnd inh_gnds inh_vdd inh_vdds) LVT_NOR2x1_PB4_AFBB
    U79 (n82 n81 n79 inh_gnd inh_gnds inh_vdd inh_vdds) LVT_NOR2x1_PB4_AFBB
    U87 (B\<25\> n12 n90 inh_gnd inh_gnds inh_vdd inh_vdds) LVT_NOR2x1_PB4_AFBB
    U88 (n92 n91 n89 inh_gnd inh_gnds inh_vdd inh_vdds) LVT_NOR2x1_PB4_AFBB
    U186 (A\<25\> n42 n91 inh_gnd inh_gnds inh_vdd inh_vdds) LVT_NOR2x1_PB4_AFBB
    U86 (n90 n89 n87 inh_gnd inh_gnds inh_vdd inh_vdds) LVT_NOR2x1_PB4_AFBB
    U94 (B\<23\> n14 n98 inh_gnd inh_gnds inh_vdd inh_vdds) LVT_NOR2x1_PB4_AFBB
    U95 (n100 n99 n97 inh_gnd inh_gnds inh_vdd inh_vdds) LVT_NOR2x1_PB4_AFBB
    U185 (A\<23\> n44 n99 inh_gnd inh_gnds inh_vdd inh_vdds) LVT_NOR2x1_PB4_AFBB
    U93 (n98 n97 n95 inh_gnd inh_gnds inh_vdd inh_vdds) LVT_NOR2x1_PB4_AFBB
    U101 (B\<21\> n16 n106 inh_gnd inh_gnds inh_vdd inh_vdds) LVT_NOR2x1_PB4_AFBB
    U102 (n108 n107 n105 inh_gnd inh_gnds inh_vdd inh_vdds) LVT_NOR2x1_PB4_AFBB
    U184 (A\<21\> n46 n107 inh_gnd inh_gnds inh_vdd inh_vdds) LVT_NOR2x1_PB4_AFBB
    U100 (n106 n105 n103 inh_gnd inh_gnds inh_vdd inh_vdds) LVT_NOR2x1_PB4_AFBB
    U108 (B\<19\> n18 n114 inh_gnd inh_gnds inh_vdd inh_vdds) LVT_NOR2x1_PB4_AFBB
    U109 (n116 n115 n113 inh_gnd inh_gnds inh_vdd inh_vdds) LVT_NOR2x1_PB4_AFBB
    U183 (A\<19\> n48 n115 inh_gnd inh_gnds inh_vdd inh_vdds) LVT_NOR2x1_PB4_AFBB
    U107 (n114 n113 n111 inh_gnd inh_gnds inh_vdd inh_vdds) LVT_NOR2x1_PB4_AFBB
    U115 (B\<17\> n20 n122 inh_gnd inh_gnds inh_vdd inh_vdds) LVT_NOR2x1_PB4_AFBB
    U116 (n124 n123 n121 inh_gnd inh_gnds inh_vdd inh_vdds) LVT_NOR2x1_PB4_AFBB
    U182 (A\<17\> n50 n123 inh_gnd inh_gnds inh_vdd inh_vdds) LVT_NOR2x1_PB4_AFBB
    U114 (n122 n121 n119 inh_gnd inh_gnds inh_vdd inh_vdds) LVT_NOR2x1_PB4_AFBB
    U122 (B\<15\> n22 n130 inh_gnd inh_gnds inh_vdd inh_vdds) LVT_NOR2x1_PB4_AFBB
    U123 (n132 n131 n129 inh_gnd inh_gnds inh_vdd inh_vdds) LVT_NOR2x1_PB4_AFBB
    U181 (A\<15\> n52 n131 inh_gnd inh_gnds inh_vdd inh_vdds) LVT_NOR2x1_PB4_AFBB
    U121 (n130 n129 n127 inh_gnd inh_gnds inh_vdd inh_vdds) LVT_NOR2x1_PB4_AFBB
    U129 (B\<13\> n24 n138 inh_gnd inh_gnds inh_vdd inh_vdds) LVT_NOR2x1_PB4_AFBB
    U130 (n140 n139 n137 inh_gnd inh_gnds inh_vdd inh_vdds) LVT_NOR2x1_PB4_AFBB
    U180 (A\<13\> n54 n139 inh_gnd inh_gnds inh_vdd inh_vdds) LVT_NOR2x1_PB4_AFBB
    U128 (n138 n137 n135 inh_gnd inh_gnds inh_vdd inh_vdds) LVT_NOR2x1_PB4_AFBB
    U136 (B\<11\> n26 n146 inh_gnd inh_gnds inh_vdd inh_vdds) LVT_NOR2x1_PB4_AFBB
    U137 (n148 n147 n145 inh_gnd inh_gnds inh_vdd inh_vdds) LVT_NOR2x1_PB4_AFBB
    U179 (A\<11\> n56 n147 inh_gnd inh_gnds inh_vdd inh_vdds) LVT_NOR2x1_PB4_AFBB
    U135 (n146 n145 n143 inh_gnd inh_gnds inh_vdd inh_vdds) LVT_NOR2x1_PB4_AFBB
    U144 (n156 n155 n153 inh_gnd inh_gnds inh_vdd inh_vdds) LVT_NOR2x1_PB4_AFBB
    U142 (n154 n153 n151 inh_gnd inh_gnds inh_vdd inh_vdds) LVT_NOR2x1_PB4_AFBB
    U143 (B\<10\> n1 n154 inh_gnd inh_gnds inh_vdd inh_vdds) LVT_NOR2x1_PB4_AFBB
    U178 (A\<9\> n2 n155 inh_gnd inh_gnds inh_vdd inh_vdds) LVT_NOR2x1_PB4_AFBB
    U150 (B\<7\> n29 n162 inh_gnd inh_gnds inh_vdd inh_vdds) LVT_NOR2x1_PB4_AFBB
    U151 (n164 n163 n161 inh_gnd inh_gnds inh_vdd inh_vdds) LVT_NOR2x1_PB4_AFBB
    U177 (A\<7\> n59 n163 inh_gnd inh_gnds inh_vdd inh_vdds) LVT_NOR2x1_PB4_AFBB
    U149 (n162 n161 n159 inh_gnd inh_gnds inh_vdd inh_vdds) LVT_NOR2x1_PB4_AFBB
    U157 (B\<5\> n31 n170 inh_gnd inh_gnds inh_vdd inh_vdds) LVT_NOR2x1_PB4_AFBB
    U158 (n172 n171 n169 inh_gnd inh_gnds inh_vdd inh_vdds) LVT_NOR2x1_PB4_AFBB
    U176 (A\<5\> n61 n171 inh_gnd inh_gnds inh_vdd inh_vdds) LVT_NOR2x1_PB4_AFBB
    U156 (n170 n169 n167 inh_gnd inh_gnds inh_vdd inh_vdds) LVT_NOR2x1_PB4_AFBB
    U164 (B\<3\> n33 n178 inh_gnd inh_gnds inh_vdd inh_vdds) LVT_NOR2x1_PB4_AFBB
    U165 (n180 n179 n177 inh_gnd inh_gnds inh_vdd inh_vdds) LVT_NOR2x1_PB4_AFBB
    U175 (A\<3\> n63 n179 inh_gnd inh_gnds inh_vdd inh_vdds) LVT_NOR2x1_PB4_AFBB
    U163 (n178 n177 n175 inh_gnd inh_gnds inh_vdd inh_vdds) LVT_NOR2x1_PB4_AFBB
    U172 (B\<1\> n188 n185 inh_gnd inh_gnds inh_vdd inh_vdds) LVT_NOR2x1_PB4_AFBB
    U173 (A\<1\> n187 n188 inh_gnd inh_gnds inh_vdd inh_vdds) LVT_NOR2x1_PB4_AFBB
    U170 (n185 n35 n183 inh_gnd inh_gnds inh_vdd inh_vdds) LVT_NOR2x1_PB4_AFBB
ends alu_sltu_DW01_cmp2_0

// power_gating_fine/alu_sltu/schematic
subckt alu_sltu pwr_en A\<31\> A\<30\> A\<29\> A\<28\> A\<27\> A\<26\> A\<25\> A\<24\> A\<23\> A\<22\> A\<21\> A\<20\> A\<19\> A\<18\> A\<17\> A\<16\> A\<15\> A\<14\> A\<13\> A\<12\> A\<11\> A\<10\> A\<9\> A\<8\> A\<7\> A\<6\> A\<5\> A\<4\> A\<3\> A\<2\> A\<1\> A\<0\> B\<31\> B\<30\> B\<29\> B\<28\> B\<27\> B\<26\> B\<25\> B\<24\> B\<23\> B\<22\> B\<21\> B\<20\> B\<19\> B\<18\> B\<17\> B\<16\> B\<15\> B\<14\> B\<13\> B\<12\> B\<11\> B\<10\> B\<9\> B\<8\> B\<7\> B\<6\> B\<5\> B\<4\> B\<3\> B\<2\> B\<1\> B\<0\> C\<31\> C\<30\> C\<29\> C\<28\> C\<27\> C\<26\> C\<25\> C\<24\> C\<23\> C\<22\> C\<21\> C\<20\> C\<19\> C\<18\> C\<17\> C\<16\> C\<15\> C\<14\> C\<13\> C\<12\> C\<11\> C\<10\> C\<9\> C\<8\> C\<7\> C\<6\> C\<5\> C\<4\> C\<3\> C\<2\> C\<1\> C\<0\> inh_gnd inh_gnds vdd_in inh_vdds
    UG160 (pwr_en pwr_en_bar inh_gnd inh_gnds vdd_in inh_vdds) LVT_invx2_PB4_AFBB
    alu_sltu_pwr_pmos (inh_vdd pwr_en_bar vdd_in inh_vdds) lvtpfet w=8000n l=30.00n nf=(2)*(1) ngcon=1 nsig_delvto_uo1=0 nsig_delvto_uo2=0 soa=1 swshe=0 swacc=0 swrg=0 swrsub=0 mismatch=1 m=1
    Thru0 (N32 C\<0\>) iprobe
    Thru31 (GND! C\<31\>) iprobe
    Thru30 (GND! C\<30\>) iprobe
    Thru29 (GND! C\<29\>) iprobe
    Thru28 (GND! C\<28\>) iprobe
    Thru27 (GND! C\<27\>) iprobe
    Thru26 (GND! C\<26\>) iprobe
    Thru25 (GND! C\<25\>) iprobe
    Thru24 (GND! C\<24\>) iprobe
    Thru23 (GND! C\<23\>) iprobe
    Thru22 (GND! C\<22\>) iprobe
    Thru21 (GND! C\<21\>) iprobe
    Thru20 (GND! C\<20\>) iprobe
    Thru19 (GND! C\<19\>) iprobe
    Thru18 (GND! C\<18\>) iprobe
    Thru17 (GND! C\<17\>) iprobe
    Thru16 (GND! C\<16\>) iprobe
    Thru15 (GND! C\<15\>) iprobe
    Thru14 (GND! C\<14\>) iprobe
    Thru13 (GND! C\<13\>) iprobe
    Thru12 (GND! C\<12\>) iprobe
    Thru11 (GND! C\<11\>) iprobe
    Thru10 (GND! C\<10\>) iprobe
    Thru9 (GND! C\<9\>) iprobe
    Thru8 (GND! C\<8\>) iprobe
    Thru7 (GND! C\<7\>) iprobe
    Thru6 (GND! C\<6\>) iprobe
    Thru5 (GND! C\<5\>) iprobe
    Thru4 (GND! C\<4\>) iprobe
    Thru3 (GND! C\<3\>) iprobe
    Thru2 (GND! C\<2\>) iprobe
    Thru1 (GND! C\<1\>) iprobe
    lt_24 (A\<31\> A\<30\> A\<29\> A\<28\> A\<27\> A\<26\> A\<25\> A\<24\> A\<23\> A\<22\> A\<21\> A\<20\> A\<19\> A\<18\> A\<17\> A\<16\> A\<15\> A\<14\> A\<13\> A\<12\> A\<11\> A\<10\> A\<9\> A\<8\> A\<7\> A\<6\> A\<5\> A\<4\> A\<3\> A\<2\> A\<1\> A\<0\> B\<31\> B\<30\> B\<29\> B\<28\> B\<27\> B\<26\> B\<25\> B\<24\> B\<23\> B\<22\> B\<21\> B\<20\> B\<19\> B\<18\> B\<17\> B\<16\> B\<15\> B\<14\> B\<13\> B\<12\> B\<11\> B\<10\> B\<9\> B\<8\> B\<7\> B\<6\> B\<5\> B\<4\> B\<3\> B\<2\> B\<1\> B\<0\> GND! GND! N32 NeTt_108 inh_gnd inh_gnds inh_vdd inh_vdds) alu_sltu_DW01_cmp2_0
ends alu_sltu

// power_gating_fine/alu/schematic
subckt alu A\<31\> A\<30\> A\<29\> A\<28\> A\<27\> A\<26\> A\<25\> A\<24\> A\<23\> A\<22\> A\<21\> A\<20\> A\<19\> A\<18\> A\<17\> A\<16\> A\<15\> A\<14\> A\<13\> A\<12\> A\<11\> A\<10\> A\<9\> A\<8\> A\<7\> A\<6\> A\<5\> A\<4\> A\<3\> A\<2\> A\<1\> A\<0\> B\<31\> B\<30\> B\<29\> B\<28\> B\<27\> B\<26\> B\<25\> B\<24\> B\<23\> B\<22\> B\<21\> B\<20\> B\<19\> B\<18\> B\<17\> B\<16\> B\<15\> B\<14\> B\<13\> B\<12\> B\<11\> B\<10\> B\<9\> B\<8\> B\<7\> B\<6\> B\<5\> B\<4\> B\<3\> B\<2\> B\<1\> B\<0\> operation\<3\> operation\<2\> operation\<1\> operation\<0\> result\<31\> result\<30\> result\<29\> result\<28\> result\<27\> result\<26\> result\<25\> result\<24\> result\<23\> result\<22\> result\<21\> result\<20\> result\<19\> result\<18\> result\<17\> result\<16\> result\<15\> result\<14\> result\<13\> result\<12\> result\<11\> result\<10\> result\<9\> result\<8\> result\<7\> result\<6\> result\<5\> result\<4\> result\<3\> result\<2\> result\<1\> result\<0\> inh_gnd inh_gnds inh_vdd inh_vdds
    U1535 (sltu_res\[0\] n795 n1463 inh_gnd inh_gnds inh_vdd inh_vdds) LVT_NADN2x1_PB4_AFBB
    U1536 (xor_res\<0\> n809 n1462 inh_gnd inh_gnds inh_vdd inh_vdds) LVT_NADN2x1_PB4_AFBB
    U1534 (n1462 n1463 n1461 inh_gnd inh_gnds inh_vdd inh_vdds) LVT_NADN2x1_PB4_AFBB
    U1537 (or_res\<0\> n837 n1459 inh_gnd inh_gnds inh_vdd inh_vdds) LVT_NADN2x1_PB4_AFBB
    U1533 (n1460 n1459 n1455 inh_gnd inh_gnds inh_vdd inh_vdds) LVT_NADN2x1_PB4_AFBB
    U1532 (srl_res\<0\> n849 n1457 inh_gnd inh_gnds inh_vdd inh_vdds) LVT_NADN2x1_PB4_AFBB
    U1531 (and_res\<0\> n803 n1458 inh_gnd inh_gnds inh_vdd inh_vdds) LVT_NADN2x1_PB4_AFBB
    U1530 (n1457 n1458 n1456 inh_gnd inh_gnds inh_vdd inh_vdds) LVT_NADN2x1_PB4_AFBB
    U1517 (n1441 n1440 n1515 inh_gnd inh_gnds inh_vdd inh_vdds) LVT_NADN2x1_PB4_AFBB
    U1525 (bpt_res\<0\> n823 n1452 inh_gnd inh_gnds inh_vdd inh_vdds) LVT_NADN2x1_PB4_AFBB
    U1520 (sll_res\<0\> n801 n1447 inh_gnd inh_gnds inh_vdd inh_vdds) LVT_NADN2x1_PB4_AFBB
    U1518 (n1443 n1444 n1442 inh_gnd inh_gnds inh_vdd inh_vdds) LVT_NADN2x1_PB4_AFBB
    U1527 (sra_res\<0\> n807 n1454 inh_gnd inh_gnds inh_vdd inh_vdds) LVT_NADN2x1_PB4_AFBB
    U1528 (add_res\<0\> n819 n1453 inh_gnd inh_gnds inh_vdd inh_vdds) LVT_NADN2x1_PB4_AFBB
    U1526 (n1453 n1454 n1450 inh_gnd inh_gnds inh_vdd inh_vdds) LVT_NADN2x1_PB4_AFBB
    U1523 (sub_res\<0\> n805 n1448 inh_gnd inh_gnds inh_vdd inh_vdds) LVT_NADN2x1_PB4_AFBB
    U1522 (slt_res\[0\] n793 n1449 inh_gnd inh_gnds inh_vdd inh_vdds) LVT_NADN2x1_PB4_AFBB
    U1521 (n1448 n1449 n1445 inh_gnd inh_gnds inh_vdd inh_vdds) LVT_NADN2x1_PB4_AFBB
    U1549 (n812 n836 n1476 inh_gnd inh_gnds inh_vdd inh_vdds) LVT_NADN2x1_PB4_AFBB
    U1516 (or_res\<10\> n837 n1438 inh_gnd inh_gnds inh_vdd inh_vdds) LVT_NADN2x1_PB4_AFBB
    U1515 (xor_res\<10\> n809 n1439 inh_gnd inh_gnds inh_vdd inh_vdds) LVT_NADN2x1_PB4_AFBB
    U1514 (n1438 n1439 n1434 inh_gnd inh_gnds inh_vdd inh_vdds) LVT_NADN2x1_PB4_AFBB
    U1513 (srl_res\<10\> n849 n1436 inh_gnd inh_gnds inh_vdd inh_vdds) LVT_NADN2x1_PB4_AFBB
    U1512 (and_res\<10\> n803 n1437 inh_gnd inh_gnds inh_vdd inh_vdds) LVT_NADN2x1_PB4_AFBB
    U1511 (n1436 n1437 n1435 inh_gnd inh_gnds inh_vdd inh_vdds) LVT_NADN2x1_PB4_AFBB
    U1500 (n1423 n1424 n1505 inh_gnd inh_gnds inh_vdd inh_vdds) LVT_NADN2x1_PB4_AFBB
    U1506 (bpt_res\<10\> n823 n1430 inh_gnd inh_gnds inh_vdd inh_vdds) LVT_NADN2x1_PB4_AFBB
    U1505 (n1429 n1430 n1425 inh_gnd inh_gnds inh_vdd inh_vdds) LVT_NADN2x1_PB4_AFBB
    U1508 (sra_res\<10\> n807 n1433 inh_gnd inh_gnds inh_vdd inh_vdds) LVT_NADN2x1_PB4_AFBB
    U1509 (n840 add_res\<10\> n1432 inh_gnd inh_gnds inh_vdd inh_vdds) LVT_NADN2x1_PB4_AFBB
    U1507 (n1432 n1433 n1431 inh_gnd inh_gnds inh_vdd inh_vdds) LVT_NADN2x1_PB4_AFBB
    U1504 (sll_res\<10\> n801 n1427 inh_gnd inh_gnds inh_vdd inh_vdds) LVT_NADN2x1_PB4_AFBB
    U1503 (sub_res\<10\> n805 n1428 inh_gnd inh_gnds inh_vdd inh_vdds) LVT_NADN2x1_PB4_AFBB
    U1502 (n1427 n1428 n1426 inh_gnd inh_gnds inh_vdd inh_vdds) LVT_NADN2x1_PB4_AFBB
    U1499 (or_res\<11\> n837 n1421 inh_gnd inh_gnds inh_vdd inh_vdds) LVT_NADN2x1_PB4_AFBB
    U1498 (xor_res\<11\> n809 n1422 inh_gnd inh_gnds inh_vdd inh_vdds) LVT_NADN2x1_PB4_AFBB
    U1497 (n1421 n1422 n1417 inh_gnd inh_gnds inh_vdd inh_vdds) LVT_NADN2x1_PB4_AFBB
    U1496 (srl_res\<11\> n849 n1419 inh_gnd inh_gnds inh_vdd inh_vdds) LVT_NADN2x1_PB4_AFBB
    U1495 (and_res\<11\> n803 n1420 inh_gnd inh_gnds inh_vdd inh_vdds) LVT_NADN2x1_PB4_AFBB
    U1494 (n1419 n1420 n1418 inh_gnd inh_gnds inh_vdd inh_vdds) LVT_NADN2x1_PB4_AFBB
    U1483 (n1406 n1407 n1504 inh_gnd inh_gnds inh_vdd inh_vdds) LVT_NADN2x1_PB4_AFBB
    U1489 (bpt_res\<11\> n823 n1413 inh_gnd inh_gnds inh_vdd inh_vdds) LVT_NADN2x1_PB4_AFBB
    U1488 (n1412 n1413 n1408 inh_gnd inh_gnds inh_vdd inh_vdds) LVT_NADN2x1_PB4_AFBB
    U1491 (sra_res\<11\> n807 n1416 inh_gnd inh_gnds inh_vdd inh_vdds) LVT_NADN2x1_PB4_AFBB
    U1492 (add_res\<11\> n838 n1415 inh_gnd inh_gnds inh_vdd inh_vdds) LVT_NADN2x1_PB4_AFBB
    U1475 (add_res\<12\> n838 n1398 inh_gnd inh_gnds inh_vdd inh_vdds) LVT_NADN2x1_PB4_AFBB
    U1490 (n1415 n1416 n1414 inh_gnd inh_gnds inh_vdd inh_vdds) LVT_NADN2x1_PB4_AFBB
    U1487 (sll_res\<11\> n801 n1410 inh_gnd inh_gnds inh_vdd inh_vdds) LVT_NADN2x1_PB4_AFBB
    U1486 (sub_res\<11\> n805 n1411 inh_gnd inh_gnds inh_vdd inh_vdds) LVT_NADN2x1_PB4_AFBB
    U1485 (n1410 n1411 n1409 inh_gnd inh_gnds inh_vdd inh_vdds) LVT_NADN2x1_PB4_AFBB
    U1482 (or_res\<12\> n837 n1404 inh_gnd inh_gnds inh_vdd inh_vdds) LVT_NADN2x1_PB4_AFBB
    U1481 (xor_res\<12\> n809 n1405 inh_gnd inh_gnds inh_vdd inh_vdds) LVT_NADN2x1_PB4_AFBB
    U1480 (n1404 n1405 n1400 inh_gnd inh_gnds inh_vdd inh_vdds) LVT_NADN2x1_PB4_AFBB
    U1479 (srl_res\<12\> n849 n1402 inh_gnd inh_gnds inh_vdd inh_vdds) LVT_NADN2x1_PB4_AFBB
    U1478 (and_res\<12\> n803 n1403 inh_gnd inh_gnds inh_vdd inh_vdds) LVT_NADN2x1_PB4_AFBB
    U1477 (n1402 n1403 n1401 inh_gnd inh_gnds inh_vdd inh_vdds) LVT_NADN2x1_PB4_AFBB
    U1466 (n1389 n1390 n1503 inh_gnd inh_gnds inh_vdd inh_vdds) LVT_NADN2x1_PB4_AFBB
    U1472 (bpt_res\<12\> n823 n1396 inh_gnd inh_gnds inh_vdd inh_vdds) LVT_NADN2x1_PB4_AFBB
    U1471 (n1395 n1396 n1391 inh_gnd inh_gnds inh_vdd inh_vdds) LVT_NADN2x1_PB4_AFBB
    U1474 (sra_res\<12\> n807 n1399 inh_gnd inh_gnds inh_vdd inh_vdds) LVT_NADN2x1_PB4_AFBB
    U1473 (n1398 n1399 n1397 inh_gnd inh_gnds inh_vdd inh_vdds) LVT_NADN2x1_PB4_AFBB
    U1470 (sll_res\<12\> n801 n1393 inh_gnd inh_gnds inh_vdd inh_vdds) LVT_NADN2x1_PB4_AFBB
    U1469 (sub_res\<12\> n805 n1394 inh_gnd inh_gnds inh_vdd inh_vdds) LVT_NADN2x1_PB4_AFBB
    U1468 (n1394 n1393 n1392 inh_gnd inh_gnds inh_vdd inh_vdds) LVT_NADN2x1_PB4_AFBB
    U1465 (or_res\<13\> n837 n1387 inh_gnd inh_gnds inh_vdd inh_vdds) LVT_NADN2x1_PB4_AFBB
    U1464 (xor_res\<13\> n809 n1388 inh_gnd inh_gnds inh_vdd inh_vdds) LVT_NADN2x1_PB4_AFBB
    U1463 (n1387 n1388 n1383 inh_gnd inh_gnds inh_vdd inh_vdds) LVT_NADN2x1_PB4_AFBB
    U1462 (srl_res\<13\> n849 n1385 inh_gnd inh_gnds inh_vdd inh_vdds) LVT_NADN2x1_PB4_AFBB
    U1461 (and_res\<13\> n803 n1386 inh_gnd inh_gnds inh_vdd inh_vdds) LVT_NADN2x1_PB4_AFBB
    U1460 (n1385 n1386 n1384 inh_gnd inh_gnds inh_vdd inh_vdds) LVT_NADN2x1_PB4_AFBB
    U1449 (n1372 n1373 n1502 inh_gnd inh_gnds inh_vdd inh_vdds) LVT_NADN2x1_PB4_AFBB
    U1455 (bpt_res\<13\> n823 n1379 inh_gnd inh_gnds inh_vdd inh_vdds) LVT_NADN2x1_PB4_AFBB
    U1454 (n1378 n1379 n1374 inh_gnd inh_gnds inh_vdd inh_vdds) LVT_NADN2x1_PB4_AFBB
    U1457 (sra_res\<13\> n807 n1382 inh_gnd inh_gnds inh_vdd inh_vdds) LVT_NADN2x1_PB4_AFBB
    U1458 (n910 add_res\<13\> n1381 inh_gnd inh_gnds inh_vdd inh_vdds) LVT_NADN2x1_PB4_AFBB
    U1456 (n1381 n1382 n1380 inh_gnd inh_gnds inh_vdd inh_vdds) LVT_NADN2x1_PB4_AFBB
    U1546 (operation\<0\> n835 n1473 inh_gnd inh_gnds inh_vdd inh_vdds) LVT_NADN2x1_PB4_AFBB
    U1558 (n811 n827 n1471 inh_gnd inh_gnds inh_vdd inh_vdds) LVT_NADN2x1_PB4_AFBB
    U1448 (or_res\<14\> n837 n1370 inh_gnd inh_gnds inh_vdd inh_vdds) LVT_NADN2x1_PB4_AFBB
    U1447 (xor_res\<14\> n809 n1371 inh_gnd inh_gnds inh_vdd inh_vdds) LVT_NADN2x1_PB4_AFBB
    U1446 (n1370 n1371 n1366 inh_gnd inh_gnds inh_vdd inh_vdds) LVT_NADN2x1_PB4_AFBB
    U1445 (srl_res\<14\> n849 n1368 inh_gnd inh_gnds inh_vdd inh_vdds) LVT_NADN2x1_PB4_AFBB
    U1444 (and_res\<14\> n803 n1369 inh_gnd inh_gnds inh_vdd inh_vdds) LVT_NADN2x1_PB4_AFBB
    U1443 (n1368 n1369 n1367 inh_gnd inh_gnds inh_vdd inh_vdds) LVT_NADN2x1_PB4_AFBB
    U1432 (n1355 n1356 n1501 inh_gnd inh_gnds inh_vdd inh_vdds) LVT_NADN2x1_PB4_AFBB
    U1438 (bpt_res\<14\> n823 n1362 inh_gnd inh_gnds inh_vdd inh_vdds) LVT_NADN2x1_PB4_AFBB
    U1437 (n1361 n1362 n1357 inh_gnd inh_gnds inh_vdd inh_vdds) LVT_NADN2x1_PB4_AFBB
    U1440 (sra_res\<14\> n807 n1365 inh_gnd inh_gnds inh_vdd inh_vdds) LVT_NADN2x1_PB4_AFBB
    U1441 (n841 add_res\<14\> n1364 inh_gnd inh_gnds inh_vdd inh_vdds) LVT_NADN2x1_PB4_AFBB
    U1373 (add_res\<18\> n841 n1296 inh_gnd inh_gnds inh_vdd inh_vdds) LVT_NADN2x1_PB4_AFBB
    U1439 (n1364 n1365 n1363 inh_gnd inh_gnds inh_vdd inh_vdds) LVT_NADN2x1_PB4_AFBB
    U1436 (sll_res\<14\> n801 n1359 inh_gnd inh_gnds inh_vdd inh_vdds) LVT_NADN2x1_PB4_AFBB
    U1435 (sub_res\<14\> n805 n1360 inh_gnd inh_gnds inh_vdd inh_vdds) LVT_NADN2x1_PB4_AFBB
    U1434 (n1359 n1360 n1358 inh_gnd inh_gnds inh_vdd inh_vdds) LVT_NADN2x1_PB4_AFBB
    U1431 (or_res\<15\> n837 n1353 inh_gnd inh_gnds inh_vdd inh_vdds) LVT_NADN2x1_PB4_AFBB
    U1430 (xor_res\<15\> n809 n1354 inh_gnd inh_gnds inh_vdd inh_vdds) LVT_NADN2x1_PB4_AFBB
    U1429 (n1353 n1354 n1349 inh_gnd inh_gnds inh_vdd inh_vdds) LVT_NADN2x1_PB4_AFBB
    U1428 (srl_res\<15\> n849 n1351 inh_gnd inh_gnds inh_vdd inh_vdds) LVT_NADN2x1_PB4_AFBB
    U1427 (and_res\<15\> n803 n1352 inh_gnd inh_gnds inh_vdd inh_vdds) LVT_NADN2x1_PB4_AFBB
    U1426 (n1351 n1352 n1350 inh_gnd inh_gnds inh_vdd inh_vdds) LVT_NADN2x1_PB4_AFBB
    U1415 (n1338 n1339 n1500 inh_gnd inh_gnds inh_vdd inh_vdds) LVT_NADN2x1_PB4_AFBB
    U1421 (bpt_res\<15\> n823 n1345 inh_gnd inh_gnds inh_vdd inh_vdds) LVT_NADN2x1_PB4_AFBB
    U1420 (n1344 n1345 n1340 inh_gnd inh_gnds inh_vdd inh_vdds) LVT_NADN2x1_PB4_AFBB
    U1423 (sra_res\<15\> n807 n1348 inh_gnd inh_gnds inh_vdd inh_vdds) LVT_NADN2x1_PB4_AFBB
    U1424 (add_res\<15\> n829 n1347 inh_gnd inh_gnds inh_vdd inh_vdds) LVT_NADN2x1_PB4_AFBB
    U1422 (n1347 n1348 n1346 inh_gnd inh_gnds inh_vdd inh_vdds) LVT_NADN2x1_PB4_AFBB
    U1419 (sll_res\<15\> n801 n1342 inh_gnd inh_gnds inh_vdd inh_vdds) LVT_NADN2x1_PB4_AFBB
    U1418 (sub_res\<15\> n805 n1343 inh_gnd inh_gnds inh_vdd inh_vdds) LVT_NADN2x1_PB4_AFBB
    U1417 (n1343 n1342 n1341 inh_gnd inh_gnds inh_vdd inh_vdds) LVT_NADN2x1_PB4_AFBB
    U1414 (or_res\<16\> n837 n1336 inh_gnd inh_gnds inh_vdd inh_vdds) LVT_NADN2x1_PB4_AFBB
    U1413 (xor_res\<16\> n809 n1337 inh_gnd inh_gnds inh_vdd inh_vdds) LVT_NADN2x1_PB4_AFBB
    U1412 (n1336 n1337 n1332 inh_gnd inh_gnds inh_vdd inh_vdds) LVT_NADN2x1_PB4_AFBB
    U1411 (srl_res\<16\> n849 n1334 inh_gnd inh_gnds inh_vdd inh_vdds) LVT_NADN2x1_PB4_AFBB
    U1410 (and_res\<16\> n803 n1335 inh_gnd inh_gnds inh_vdd inh_vdds) LVT_NADN2x1_PB4_AFBB
    U1409 (n1334 n1335 n1333 inh_gnd inh_gnds inh_vdd inh_vdds) LVT_NADN2x1_PB4_AFBB
    U1398 (n1321 n1322 n1499 inh_gnd inh_gnds inh_vdd inh_vdds) LVT_NADN2x1_PB4_AFBB
    U1404 (bpt_res\<16\> n823 n1328 inh_gnd inh_gnds inh_vdd inh_vdds) LVT_NADN2x1_PB4_AFBB
    U1403 (n1327 n1328 n1323 inh_gnd inh_gnds inh_vdd inh_vdds) LVT_NADN2x1_PB4_AFBB
    U1406 (sra_res\<16\> n807 n1331 inh_gnd inh_gnds inh_vdd inh_vdds) LVT_NADN2x1_PB4_AFBB
    U1407 (n839 add_res\<16\> n1330 inh_gnd inh_gnds inh_vdd inh_vdds) LVT_NADN2x1_PB4_AFBB
    U1356 (n839 add_res\<19\> n1279 inh_gnd inh_gnds inh_vdd inh_vdds) LVT_NADN2x1_PB4_AFBB
    U1405 (n1330 n1331 n1329 inh_gnd inh_gnds inh_vdd inh_vdds) LVT_NADN2x1_PB4_AFBB
    U1402 (sll_res\<16\> n801 n1325 inh_gnd inh_gnds inh_vdd inh_vdds) LVT_NADN2x1_PB4_AFBB
    U1401 (sub_res\<16\> n805 n1326 inh_gnd inh_gnds inh_vdd inh_vdds) LVT_NADN2x1_PB4_AFBB
    U1400 (n1325 n1326 n1324 inh_gnd inh_gnds inh_vdd inh_vdds) LVT_NADN2x1_PB4_AFBB
    U1397 (or_res\<17\> n837 n1319 inh_gnd inh_gnds inh_vdd inh_vdds) LVT_NADN2x1_PB4_AFBB
    U1396 (xor_res\<17\> n809 n1320 inh_gnd inh_gnds inh_vdd inh_vdds) LVT_NADN2x1_PB4_AFBB
    U1395 (n1319 n1320 n1315 inh_gnd inh_gnds inh_vdd inh_vdds) LVT_NADN2x1_PB4_AFBB
    U1394 (srl_res\<17\> n849 n1317 inh_gnd inh_gnds inh_vdd inh_vdds) LVT_NADN2x1_PB4_AFBB
    U1393 (and_res\<17\> n803 n1318 inh_gnd inh_gnds inh_vdd inh_vdds) LVT_NADN2x1_PB4_AFBB
    U1392 (n1317 n1318 n1316 inh_gnd inh_gnds inh_vdd inh_vdds) LVT_NADN2x1_PB4_AFBB
    U1381 (n1304 n1305 n1498 inh_gnd inh_gnds inh_vdd inh_vdds) LVT_NADN2x1_PB4_AFBB
    U1387 (bpt_res\<17\> n823 n1311 inh_gnd inh_gnds inh_vdd inh_vdds) LVT_NADN2x1_PB4_AFBB
    U1386 (n1310 n1311 n1306 inh_gnd inh_gnds inh_vdd inh_vdds) LVT_NADN2x1_PB4_AFBB
    U1389 (sra_res\<17\> n807 n1314 inh_gnd inh_gnds inh_vdd inh_vdds) LVT_NADN2x1_PB4_AFBB
    U1390 (n909 add_res\<17\> n1313 inh_gnd inh_gnds inh_vdd inh_vdds) LVT_NADN2x1_PB4_AFBB
    U1388 (n1313 n1314 n1312 inh_gnd inh_gnds inh_vdd inh_vdds) LVT_NADN2x1_PB4_AFBB
    U1385 (sll_res\<17\> n801 n1308 inh_gnd inh_gnds inh_vdd inh_vdds) LVT_NADN2x1_PB4_AFBB
    U1384 (sub_res\<17\> n805 n1309 inh_gnd inh_gnds inh_vdd inh_vdds) LVT_NADN2x1_PB4_AFBB
    U1383 (n1308 n1309 n1307 inh_gnd inh_gnds inh_vdd inh_vdds) LVT_NADN2x1_PB4_AFBB
    U1380 (or_res\<18\> n837 n1302 inh_gnd inh_gnds inh_vdd inh_vdds) LVT_NADN2x1_PB4_AFBB
    U1379 (xor_res\<18\> n809 n1303 inh_gnd inh_gnds inh_vdd inh_vdds) LVT_NADN2x1_PB4_AFBB
    U1378 (n1302 n1303 n1298 inh_gnd inh_gnds inh_vdd inh_vdds) LVT_NADN2x1_PB4_AFBB
    U1377 (srl_res\<18\> n849 n1300 inh_gnd inh_gnds inh_vdd inh_vdds) LVT_NADN2x1_PB4_AFBB
    U1376 (and_res\<18\> n803 n1301 inh_gnd inh_gnds inh_vdd inh_vdds) LVT_NADN2x1_PB4_AFBB
    U1375 (n1300 n1301 n1299 inh_gnd inh_gnds inh_vdd inh_vdds) LVT_NADN2x1_PB4_AFBB
    U1364 (n1287 n1288 n1497 inh_gnd inh_gnds inh_vdd inh_vdds) LVT_NADN2x1_PB4_AFBB
    U1370 (bpt_res\<18\> n823 n1294 inh_gnd inh_gnds inh_vdd inh_vdds) LVT_NADN2x1_PB4_AFBB
    U1369 (n1293 n1294 n1289 inh_gnd inh_gnds inh_vdd inh_vdds) LVT_NADN2x1_PB4_AFBB
    U1372 (sra_res\<18\> n807 n1297 inh_gnd inh_gnds inh_vdd inh_vdds) LVT_NADN2x1_PB4_AFBB
    U1371 (n1296 n1297 n1295 inh_gnd inh_gnds inh_vdd inh_vdds) LVT_NADN2x1_PB4_AFBB
    U1368 (sll_res\<18\> n801 n1291 inh_gnd inh_gnds inh_vdd inh_vdds) LVT_NADN2x1_PB4_AFBB
    U1367 (sub_res\<18\> n805 n1292 inh_gnd inh_gnds inh_vdd inh_vdds) LVT_NADN2x1_PB4_AFBB
    U1366 (n1291 n1292 n1290 inh_gnd inh_gnds inh_vdd inh_vdds) LVT_NADN2x1_PB4_AFBB
    U1363 (or_res\<19\> n837 n1285 inh_gnd inh_gnds inh_vdd inh_vdds) LVT_NADN2x1_PB4_AFBB
    U1362 (xor_res\<19\> n809 n1286 inh_gnd inh_gnds inh_vdd inh_vdds) LVT_NADN2x1_PB4_AFBB
    U1361 (n1285 n1286 n1281 inh_gnd inh_gnds inh_vdd inh_vdds) LVT_NADN2x1_PB4_AFBB
    U1360 (srl_res\<19\> n849 n1283 inh_gnd inh_gnds inh_vdd inh_vdds) LVT_NADN2x1_PB4_AFBB
    U1359 (and_res\<19\> n803 n1284 inh_gnd inh_gnds inh_vdd inh_vdds) LVT_NADN2x1_PB4_AFBB
    U1358 (n1283 n1284 n1282 inh_gnd inh_gnds inh_vdd inh_vdds) LVT_NADN2x1_PB4_AFBB
    U1347 (n1270 n1271 n1496 inh_gnd inh_gnds inh_vdd inh_vdds) LVT_NADN2x1_PB4_AFBB
    U1353 (bpt_res\<19\> n823 n1277 inh_gnd inh_gnds inh_vdd inh_vdds) LVT_NADN2x1_PB4_AFBB
    U1352 (n1276 n1277 n1272 inh_gnd inh_gnds inh_vdd inh_vdds) LVT_NADN2x1_PB4_AFBB
    U1355 (sra_res\<19\> n807 n1280 inh_gnd inh_gnds inh_vdd inh_vdds) LVT_NADN2x1_PB4_AFBB
    U1354 (n1279 n1280 n1278 inh_gnd inh_gnds inh_vdd inh_vdds) LVT_NADN2x1_PB4_AFBB
    U1453 (sll_res\<13\> n801 n1376 inh_gnd inh_gnds inh_vdd inh_vdds) LVT_NADN2x1_PB4_AFBB
    U1451 (n1377 n1376 n1375 inh_gnd inh_gnds inh_vdd inh_vdds) LVT_NADN2x1_PB4_AFBB
    U1452 (sub_res\<13\> n805 n1377 inh_gnd inh_gnds inh_vdd inh_vdds) LVT_NADN2x1_PB4_AFBB
    U1346 (or_res\<1\> n837 n1268 inh_gnd inh_gnds inh_vdd inh_vdds) LVT_NADN2x1_PB4_AFBB
    U1345 (xor_res\<1\> n809 n1269 inh_gnd inh_gnds inh_vdd inh_vdds) LVT_NADN2x1_PB4_AFBB
    U1344 (n1268 n1269 n1264 inh_gnd inh_gnds inh_vdd inh_vdds) LVT_NADN2x1_PB4_AFBB
    U1343 (srl_res\<1\> n849 n1266 inh_gnd inh_gnds inh_vdd inh_vdds) LVT_NADN2x1_PB4_AFBB
    U1342 (and_res\<1\> n803 n1267 inh_gnd inh_gnds inh_vdd inh_vdds) LVT_NADN2x1_PB4_AFBB
    U1341 (n1266 n1267 n1265 inh_gnd inh_gnds inh_vdd inh_vdds) LVT_NADN2x1_PB4_AFBB
    U1330 (n1253 n1254 n1514 inh_gnd inh_gnds inh_vdd inh_vdds) LVT_NADN2x1_PB4_AFBB
    U1336 (bpt_res\<1\> n823 n1260 inh_gnd inh_gnds inh_vdd inh_vdds) LVT_NADN2x1_PB4_AFBB
    U1335 (n1259 n1260 n1255 inh_gnd inh_gnds inh_vdd inh_vdds) LVT_NADN2x1_PB4_AFBB
    U1338 (sra_res\<1\> n807 n1263 inh_gnd inh_gnds inh_vdd inh_vdds) LVT_NADN2x1_PB4_AFBB
    U1339 (n841 add_res\<1\> n1262 inh_gnd inh_gnds inh_vdd inh_vdds) LVT_NADN2x1_PB4_AFBB
    U1337 (n1262 n1263 n1261 inh_gnd inh_gnds inh_vdd inh_vdds) LVT_NADN2x1_PB4_AFBB
    U1334 (sll_res\<1\> n801 n1257 inh_gnd inh_gnds inh_vdd inh_vdds) LVT_NADN2x1_PB4_AFBB
    U1333 (sub_res\<1\> n805 n1258 inh_gnd inh_gnds inh_vdd inh_vdds) LVT_NADN2x1_PB4_AFBB
    U1332 (n1257 n1258 n1256 inh_gnd inh_gnds inh_vdd inh_vdds) LVT_NADN2x1_PB4_AFBB
    U1329 (or_res\<20\> n837 n1251 inh_gnd inh_gnds inh_vdd inh_vdds) LVT_NADN2x1_PB4_AFBB
    U1328 (xor_res\<20\> n809 n1252 inh_gnd inh_gnds inh_vdd inh_vdds) LVT_NADN2x1_PB4_AFBB
    U1327 (n1251 n1252 n1247 inh_gnd inh_gnds inh_vdd inh_vdds) LVT_NADN2x1_PB4_AFBB
    U1326 (srl_res\<20\> n849 n1249 inh_gnd inh_gnds inh_vdd inh_vdds) LVT_NADN2x1_PB4_AFBB
    U1325 (and_res\<20\> n803 n1250 inh_gnd inh_gnds inh_vdd inh_vdds) LVT_NADN2x1_PB4_AFBB
    U1324 (n1249 n1250 n1248 inh_gnd inh_gnds inh_vdd inh_vdds) LVT_NADN2x1_PB4_AFBB
    U1313 (n1236 n1237 n1495 inh_gnd inh_gnds inh_vdd inh_vdds) LVT_NADN2x1_PB4_AFBB
    U1319 (bpt_res\<20\> n823 n1243 inh_gnd inh_gnds inh_vdd inh_vdds) LVT_NADN2x1_PB4_AFBB
    U1318 (n1242 n1243 n1238 inh_gnd inh_gnds inh_vdd inh_vdds) LVT_NADN2x1_PB4_AFBB
    U1321 (sra_res\<20\> n807 n1246 inh_gnd inh_gnds inh_vdd inh_vdds) LVT_NADN2x1_PB4_AFBB
    U1322 (n911 add_res\<20\> n1245 inh_gnd inh_gnds inh_vdd inh_vdds) LVT_NADN2x1_PB4_AFBB
    U1320 (n1245 n1246 n1244 inh_gnd inh_gnds inh_vdd inh_vdds) LVT_NADN2x1_PB4_AFBB
    U1317 (sll_res\<20\> n801 n1240 inh_gnd inh_gnds inh_vdd inh_vdds) LVT_NADN2x1_PB4_AFBB
    U1316 (sub_res\<20\> n805 n1241 inh_gnd inh_gnds inh_vdd inh_vdds) LVT_NADN2x1_PB4_AFBB
    U1315 (n1240 n1241 n1239 inh_gnd inh_gnds inh_vdd inh_vdds) LVT_NADN2x1_PB4_AFBB
    U1312 (or_res\<21\> n837 n1234 inh_gnd inh_gnds inh_vdd inh_vdds) LVT_NADN2x1_PB4_AFBB
    U1311 (xor_res\<21\> n809 n1235 inh_gnd inh_gnds inh_vdd inh_vdds) LVT_NADN2x1_PB4_AFBB
    U1310 (n1234 n1235 n1230 inh_gnd inh_gnds inh_vdd inh_vdds) LVT_NADN2x1_PB4_AFBB
    U1309 (srl_res\<21\> n849 n1232 inh_gnd inh_gnds inh_vdd inh_vdds) LVT_NADN2x1_PB4_AFBB
    U1308 (and_res\<21\> n803 n1233 inh_gnd inh_gnds inh_vdd inh_vdds) LVT_NADN2x1_PB4_AFBB
    U1307 (n1232 n1233 n1231 inh_gnd inh_gnds inh_vdd inh_vdds) LVT_NADN2x1_PB4_AFBB
    U1296 (n1219 n1220 n1494 inh_gnd inh_gnds inh_vdd inh_vdds) LVT_NADN2x1_PB4_AFBB
    U1302 (bpt_res\<21\> n823 n1226 inh_gnd inh_gnds inh_vdd inh_vdds) LVT_NADN2x1_PB4_AFBB
    U1301 (n1225 n1226 n1221 inh_gnd inh_gnds inh_vdd inh_vdds) LVT_NADN2x1_PB4_AFBB
    U1304 (sra_res\<21\> n807 n1229 inh_gnd inh_gnds inh_vdd inh_vdds) LVT_NADN2x1_PB4_AFBB
    U1305 (add_res\<21\> n839 n1228 inh_gnd inh_gnds inh_vdd inh_vdds) LVT_NADN2x1_PB4_AFBB
    U1303 (n1228 n1229 n1227 inh_gnd inh_gnds inh_vdd inh_vdds) LVT_NADN2x1_PB4_AFBB
    U1300 (sll_res\<21\> n801 n1223 inh_gnd inh_gnds inh_vdd inh_vdds) LVT_NADN2x1_PB4_AFBB
    U1299 (sub_res\<21\> n805 n1224 inh_gnd inh_gnds inh_vdd inh_vdds) LVT_NADN2x1_PB4_AFBB
    U1298 (n1223 n1224 n1222 inh_gnd inh_gnds inh_vdd inh_vdds) LVT_NADN2x1_PB4_AFBB
    U1295 (or_res\<22\> n837 n1217 inh_gnd inh_gnds inh_vdd inh_vdds) LVT_NADN2x1_PB4_AFBB
    U1294 (xor_res\<22\> n809 n1218 inh_gnd inh_gnds inh_vdd inh_vdds) LVT_NADN2x1_PB4_AFBB
    U1293 (n1217 n1218 n1213 inh_gnd inh_gnds inh_vdd inh_vdds) LVT_NADN2x1_PB4_AFBB
    U1292 (srl_res\<22\> n849 n1215 inh_gnd inh_gnds inh_vdd inh_vdds) LVT_NADN2x1_PB4_AFBB
    U1291 (and_res\<22\> n803 n1216 inh_gnd inh_gnds inh_vdd inh_vdds) LVT_NADN2x1_PB4_AFBB
    U1290 (n1215 n1216 n1214 inh_gnd inh_gnds inh_vdd inh_vdds) LVT_NADN2x1_PB4_AFBB
    U1279 (n1202 n1203 n1493 inh_gnd inh_gnds inh_vdd inh_vdds) LVT_NADN2x1_PB4_AFBB
    U1285 (bpt_res\<22\> n823 n1209 inh_gnd inh_gnds inh_vdd inh_vdds) LVT_NADN2x1_PB4_AFBB
    U1284 (n1208 n1209 n1204 inh_gnd inh_gnds inh_vdd inh_vdds) LVT_NADN2x1_PB4_AFBB
    U1287 (sra_res\<22\> n807 n1212 inh_gnd inh_gnds inh_vdd inh_vdds) LVT_NADN2x1_PB4_AFBB
    U1288 (n910 add_res\<22\> n1211 inh_gnd inh_gnds inh_vdd inh_vdds) LVT_NADN2x1_PB4_AFBB
    U1286 (n1211 n1212 n1210 inh_gnd inh_gnds inh_vdd inh_vdds) LVT_NADN2x1_PB4_AFBB
    U1283 (sll_res\<22\> n801 n1206 inh_gnd inh_gnds inh_vdd inh_vdds) LVT_NADN2x1_PB4_AFBB
    U1282 (sub_res\<22\> n805 n1207 inh_gnd inh_gnds inh_vdd inh_vdds) LVT_NADN2x1_PB4_AFBB
    U1281 (n1206 n1207 n1205 inh_gnd inh_gnds inh_vdd inh_vdds) LVT_NADN2x1_PB4_AFBB
    U1237 (n838 add_res\<25\> n1160 inh_gnd inh_gnds inh_vdd inh_vdds) LVT_NADN2x1_PB4_AFBB
    U1236 (sra_res\<25\> n807 n1161 inh_gnd inh_gnds inh_vdd inh_vdds) LVT_NADN2x1_PB4_AFBB
    U1235 (n1160 n1161 n1159 inh_gnd inh_gnds inh_vdd inh_vdds) LVT_NADN2x1_PB4_AFBB
    U1234 (bpt_res\<25\> n823 n1158 inh_gnd inh_gnds inh_vdd inh_vdds) LVT_NADN2x1_PB4_AFBB
    U1233 (n1157 n1158 n1153 inh_gnd inh_gnds inh_vdd inh_vdds) LVT_NADN2x1_PB4_AFBB
    U1232 (sll_res\<25\> n801 n1155 inh_gnd inh_gnds inh_vdd inh_vdds) LVT_NADN2x1_PB4_AFBB
    U1231 (sub_res\<25\> n805 n1156 inh_gnd inh_gnds inh_vdd inh_vdds) LVT_NADN2x1_PB4_AFBB
    U1230 (n1156 n1155 n1154 inh_gnd inh_gnds inh_vdd inh_vdds) LVT_NADN2x1_PB4_AFBB
    U1228 (n1151 n1152 n1490 inh_gnd inh_gnds inh_vdd inh_vdds) LVT_NADN2x1_PB4_AFBB
    U1244 (or_res\<25\> n837 n1166 inh_gnd inh_gnds inh_vdd inh_vdds) LVT_NADN2x1_PB4_AFBB
    U1243 (xor_res\<25\> n809 n1167 inh_gnd inh_gnds inh_vdd inh_vdds) LVT_NADN2x1_PB4_AFBB
    U1242 (n1166 n1167 n1162 inh_gnd inh_gnds inh_vdd inh_vdds) LVT_NADN2x1_PB4_AFBB
    U1241 (srl_res\<25\> n849 n1164 inh_gnd inh_gnds inh_vdd inh_vdds) LVT_NADN2x1_PB4_AFBB
    U1240 (and_res\<25\> n803 n1165 inh_gnd inh_gnds inh_vdd inh_vdds) LVT_NADN2x1_PB4_AFBB
    U1239 (n1164 n1165 n1163 inh_gnd inh_gnds inh_vdd inh_vdds) LVT_NADN2x1_PB4_AFBB
    U1016 (n910 add_res\<8\> n940 inh_gnd inh_gnds inh_vdd inh_vdds) LVT_NADN2x1_PB4_AFBB
    U1015 (sra_res\<8\> n807 n941 inh_gnd inh_gnds inh_vdd inh_vdds) LVT_NADN2x1_PB4_AFBB
    U1014 (n940 n941 n939 inh_gnd inh_gnds inh_vdd inh_vdds) LVT_NADN2x1_PB4_AFBB
    U1013 (bpt_res\<8\> n823 n938 inh_gnd inh_gnds inh_vdd inh_vdds) LVT_NADN2x1_PB4_AFBB
    U1012 (n937 n938 n933 inh_gnd inh_gnds inh_vdd inh_vdds) LVT_NADN2x1_PB4_AFBB
    U1351 (sll_res\<19\> n801 n1274 inh_gnd inh_gnds inh_vdd inh_vdds) LVT_NADN2x1_PB4_AFBB
    U1349 (n1274 n1275 n1273 inh_gnd inh_gnds inh_vdd inh_vdds) LVT_NADN2x1_PB4_AFBB
    U1350 (sub_res\<19\> n805 n1275 inh_gnd inh_gnds inh_vdd inh_vdds) LVT_NADN2x1_PB4_AFBB
    U1555 (operation\<2\> n1483 n1482 inh_gnd inh_gnds inh_vdd inh_vdds) LVT_NADN2x1_PB4_AFBB
    U1278 (or_res\<23\> n837 n1200 inh_gnd inh_gnds inh_vdd inh_vdds) LVT_NADN2x1_PB4_AFBB
    U1277 (xor_res\<23\> n809 n1201 inh_gnd inh_gnds inh_vdd inh_vdds) LVT_NADN2x1_PB4_AFBB
    U1276 (n1200 n1201 n1196 inh_gnd inh_gnds inh_vdd inh_vdds) LVT_NADN2x1_PB4_AFBB
    U1275 (srl_res\<23\> n849 n1198 inh_gnd inh_gnds inh_vdd inh_vdds) LVT_NADN2x1_PB4_AFBB
    U1274 (and_res\<23\> n803 n1199 inh_gnd inh_gnds inh_vdd inh_vdds) LVT_NADN2x1_PB4_AFBB
    U1273 (n1198 n1199 n1197 inh_gnd inh_gnds inh_vdd inh_vdds) LVT_NADN2x1_PB4_AFBB
    U1262 (n1185 n1186 n1492 inh_gnd inh_gnds inh_vdd inh_vdds) LVT_NADN2x1_PB4_AFBB
    U1268 (bpt_res\<23\> n823 n1192 inh_gnd inh_gnds inh_vdd inh_vdds) LVT_NADN2x1_PB4_AFBB
    U1267 (n1191 n1192 n1187 inh_gnd inh_gnds inh_vdd inh_vdds) LVT_NADN2x1_PB4_AFBB
    U1270 (sra_res\<23\> n807 n1195 inh_gnd inh_gnds inh_vdd inh_vdds) LVT_NADN2x1_PB4_AFBB
    U1271 (n840 add_res\<23\> n1194 inh_gnd inh_gnds inh_vdd inh_vdds) LVT_NADN2x1_PB4_AFBB
    U1269 (n1194 n1195 n1193 inh_gnd inh_gnds inh_vdd inh_vdds) LVT_NADN2x1_PB4_AFBB
    U1266 (sll_res\<23\> n801 n1189 inh_gnd inh_gnds inh_vdd inh_vdds) LVT_NADN2x1_PB4_AFBB
    U1265 (sub_res\<23\> n805 n1190 inh_gnd inh_gnds inh_vdd inh_vdds) LVT_NADN2x1_PB4_AFBB
    U1264 (n1189 n1190 n1188 inh_gnd inh_gnds inh_vdd inh_vdds) LVT_NADN2x1_PB4_AFBB
    U1261 (or_res\<24\> n837 n1183 inh_gnd inh_gnds inh_vdd inh_vdds) LVT_NADN2x1_PB4_AFBB
    U1260 (xor_res\<24\> n809 n1184 inh_gnd inh_gnds inh_vdd inh_vdds) LVT_NADN2x1_PB4_AFBB
    U1259 (n1183 n1184 n1179 inh_gnd inh_gnds inh_vdd inh_vdds) LVT_NADN2x1_PB4_AFBB
    U1258 (srl_res\<24\> n849 n1181 inh_gnd inh_gnds inh_vdd inh_vdds) LVT_NADN2x1_PB4_AFBB
    U1257 (and_res\<24\> n803 n1182 inh_gnd inh_gnds inh_vdd inh_vdds) LVT_NADN2x1_PB4_AFBB
    U1256 (n1181 n1182 n1180 inh_gnd inh_gnds inh_vdd inh_vdds) LVT_NADN2x1_PB4_AFBB
    U1245 (n1168 n1169 n1491 inh_gnd inh_gnds inh_vdd inh_vdds) LVT_NADN2x1_PB4_AFBB
    U1251 (bpt_res\<24\> n823 n1175 inh_gnd inh_gnds inh_vdd inh_vdds) LVT_NADN2x1_PB4_AFBB
    U1250 (n1174 n1175 n1170 inh_gnd inh_gnds inh_vdd inh_vdds) LVT_NADN2x1_PB4_AFBB
    U1253 (sra_res\<24\> n807 n1178 inh_gnd inh_gnds inh_vdd inh_vdds) LVT_NADN2x1_PB4_AFBB
    U1254 (n909 add_res\<24\> n1177 inh_gnd inh_gnds inh_vdd inh_vdds) LVT_NADN2x1_PB4_AFBB
    U1252 (n1177 n1178 n1176 inh_gnd inh_gnds inh_vdd inh_vdds) LVT_NADN2x1_PB4_AFBB
    U1249 (sll_res\<24\> n801 n1172 inh_gnd inh_gnds inh_vdd inh_vdds) LVT_NADN2x1_PB4_AFBB
    U1248 (sub_res\<24\> n805 n1173 inh_gnd inh_gnds inh_vdd inh_vdds) LVT_NADN2x1_PB4_AFBB
    U1247 (n1172 n1173 n1171 inh_gnd inh_gnds inh_vdd inh_vdds) LVT_NADN2x1_PB4_AFBB
    U1227 (or_res\<26\> n837 n1149 inh_gnd inh_gnds inh_vdd inh_vdds) LVT_NADN2x1_PB4_AFBB
    U1226 (xor_res\<26\> n809 n1150 inh_gnd inh_gnds inh_vdd inh_vdds) LVT_NADN2x1_PB4_AFBB
    U1225 (n1149 n1150 n1145 inh_gnd inh_gnds inh_vdd inh_vdds) LVT_NADN2x1_PB4_AFBB
    U1224 (srl_res\<26\> n849 n1147 inh_gnd inh_gnds inh_vdd inh_vdds) LVT_NADN2x1_PB4_AFBB
    U1223 (and_res\<26\> n803 n1148 inh_gnd inh_gnds inh_vdd inh_vdds) LVT_NADN2x1_PB4_AFBB
    U1222 (n1147 n1148 n1146 inh_gnd inh_gnds inh_vdd inh_vdds) LVT_NADN2x1_PB4_AFBB
    U1211 (n1134 n1135 n1489 inh_gnd inh_gnds inh_vdd inh_vdds) LVT_NADN2x1_PB4_AFBB
    U1217 (bpt_res\<26\> n823 n1141 inh_gnd inh_gnds inh_vdd inh_vdds) LVT_NADN2x1_PB4_AFBB
    U1216 (n1140 n1141 n1136 inh_gnd inh_gnds inh_vdd inh_vdds) LVT_NADN2x1_PB4_AFBB
    U1219 (sra_res\<26\> n807 n1144 inh_gnd inh_gnds inh_vdd inh_vdds) LVT_NADN2x1_PB4_AFBB
    U1220 (n822 add_res\<26\> n1143 inh_gnd inh_gnds inh_vdd inh_vdds) LVT_NADN2x1_PB4_AFBB
    U1218 (n1143 n1144 n1142 inh_gnd inh_gnds inh_vdd inh_vdds) LVT_NADN2x1_PB4_AFBB
    U1215 (sll_res\<26\> n801 n1138 inh_gnd inh_gnds inh_vdd inh_vdds) LVT_NADN2x1_PB4_AFBB
    U1214 (sub_res\<26\> n805 n1139 inh_gnd inh_gnds inh_vdd inh_vdds) LVT_NADN2x1_PB4_AFBB
    U1213 (n1138 n1139 n1137 inh_gnd inh_gnds inh_vdd inh_vdds) LVT_NADN2x1_PB4_AFBB
    U1210 (or_res\<27\> n837 n1132 inh_gnd inh_gnds inh_vdd inh_vdds) LVT_NADN2x1_PB4_AFBB
    U1209 (xor_res\<27\> n809 n1133 inh_gnd inh_gnds inh_vdd inh_vdds) LVT_NADN2x1_PB4_AFBB
    U1208 (n1132 n1133 n1128 inh_gnd inh_gnds inh_vdd inh_vdds) LVT_NADN2x1_PB4_AFBB
    U1207 (srl_res\<27\> n849 n1130 inh_gnd inh_gnds inh_vdd inh_vdds) LVT_NADN2x1_PB4_AFBB
    U1206 (and_res\<27\> n803 n1131 inh_gnd inh_gnds inh_vdd inh_vdds) LVT_NADN2x1_PB4_AFBB
    U1205 (n1130 n1131 n1129 inh_gnd inh_gnds inh_vdd inh_vdds) LVT_NADN2x1_PB4_AFBB
    U1194 (n1117 n1118 n1488 inh_gnd inh_gnds inh_vdd inh_vdds) LVT_NADN2x1_PB4_AFBB
    U1200 (bpt_res\<27\> n823 n1124 inh_gnd inh_gnds inh_vdd inh_vdds) LVT_NADN2x1_PB4_AFBB
    U1199 (n1123 n1124 n1119 inh_gnd inh_gnds inh_vdd inh_vdds) LVT_NADN2x1_PB4_AFBB
    U1202 (sra_res\<27\> n807 n1127 inh_gnd inh_gnds inh_vdd inh_vdds) LVT_NADN2x1_PB4_AFBB
    U1203 (add_res\<27\> n819 n1126 inh_gnd inh_gnds inh_vdd inh_vdds) LVT_NADN2x1_PB4_AFBB
    U1201 (n1126 n1127 n1125 inh_gnd inh_gnds inh_vdd inh_vdds) LVT_NADN2x1_PB4_AFBB
    U1198 (sll_res\<27\> n801 n1121 inh_gnd inh_gnds inh_vdd inh_vdds) LVT_NADN2x1_PB4_AFBB
    U1197 (sub_res\<27\> n805 n1122 inh_gnd inh_gnds inh_vdd inh_vdds) LVT_NADN2x1_PB4_AFBB
    U1196 (n1122 n1121 n1120 inh_gnd inh_gnds inh_vdd inh_vdds) LVT_NADN2x1_PB4_AFBB
    U1193 (or_res\<28\> n837 n1115 inh_gnd inh_gnds inh_vdd inh_vdds) LVT_NADN2x1_PB4_AFBB
    U1192 (xor_res\<28\> n809 n1116 inh_gnd inh_gnds inh_vdd inh_vdds) LVT_NADN2x1_PB4_AFBB
    U1191 (n1115 n1116 n1111 inh_gnd inh_gnds inh_vdd inh_vdds) LVT_NADN2x1_PB4_AFBB
    U1190 (srl_res\<28\> n849 n1113 inh_gnd inh_gnds inh_vdd inh_vdds) LVT_NADN2x1_PB4_AFBB
    U1189 (and_res\<28\> n803 n1114 inh_gnd inh_gnds inh_vdd inh_vdds) LVT_NADN2x1_PB4_AFBB
    U1188 (n1113 n1114 n1112 inh_gnd inh_gnds inh_vdd inh_vdds) LVT_NADN2x1_PB4_AFBB
    U1177 (n1100 n1101 n1487 inh_gnd inh_gnds inh_vdd inh_vdds) LVT_NADN2x1_PB4_AFBB
    U1183 (bpt_res\<28\> n823 n1107 inh_gnd inh_gnds inh_vdd inh_vdds) LVT_NADN2x1_PB4_AFBB
    U1182 (n1106 n1107 n1102 inh_gnd inh_gnds inh_vdd inh_vdds) LVT_NADN2x1_PB4_AFBB
    U1185 (sra_res\<28\> n807 n1110 inh_gnd inh_gnds inh_vdd inh_vdds) LVT_NADN2x1_PB4_AFBB
    U1186 (n912 add_res\<28\> n1109 inh_gnd inh_gnds inh_vdd inh_vdds) LVT_NADN2x1_PB4_AFBB
    U1184 (n1109 n1110 n1108 inh_gnd inh_gnds inh_vdd inh_vdds) LVT_NADN2x1_PB4_AFBB
    U1181 (sll_res\<28\> n801 n1104 inh_gnd inh_gnds inh_vdd inh_vdds) LVT_NADN2x1_PB4_AFBB
    U1180 (sub_res\<28\> n805 n1105 inh_gnd inh_gnds inh_vdd inh_vdds) LVT_NADN2x1_PB4_AFBB
    U1179 (n1104 n1105 n1103 inh_gnd inh_gnds inh_vdd inh_vdds) LVT_NADN2x1_PB4_AFBB
    U1176 (or_res\<29\> n837 n1098 inh_gnd inh_gnds inh_vdd inh_vdds) LVT_NADN2x1_PB4_AFBB
    U1175 (xor_res\<29\> n809 n1099 inh_gnd inh_gnds inh_vdd inh_vdds) LVT_NADN2x1_PB4_AFBB
    U1174 (n1098 n1099 n1094 inh_gnd inh_gnds inh_vdd inh_vdds) LVT_NADN2x1_PB4_AFBB
    U1173 (srl_res\<29\> n849 n1096 inh_gnd inh_gnds inh_vdd inh_vdds) LVT_NADN2x1_PB4_AFBB
    U1172 (and_res\<29\> n803 n1097 inh_gnd inh_gnds inh_vdd inh_vdds) LVT_NADN2x1_PB4_AFBB
    U1171 (n1096 n1097 n1095 inh_gnd inh_gnds inh_vdd inh_vdds) LVT_NADN2x1_PB4_AFBB
    U1556 (operation\<0\> n1467 n1465 inh_gnd inh_gnds inh_vdd inh_vdds) LVT_NADN2x1_PB4_AFBB
    U1551 (n1472 n1479 n1477 inh_gnd inh_gnds inh_vdd inh_vdds) LVT_NADN2x1_PB4_AFBB
    U1542 (n1470 n1468 n1469 inh_gnd inh_gnds inh_vdd inh_vdds) LVT_NADN2x1_PB4_AFBB
    U1540 (operation\<0\> n1468 n1466 inh_gnd inh_gnds inh_vdd inh_vdds) LVT_NADN2x1_PB4_AFBB
    U1163 (sub_res\<29\> n805 n1088 inh_gnd inh_gnds inh_vdd inh_vdds) LVT_NADN2x1_PB4_AFBB
    U1164 (sll_res\<29\> n801 n1087 inh_gnd inh_gnds inh_vdd inh_vdds) LVT_NADN2x1_PB4_AFBB
    U1160 (n1083 n1084 n1486 inh_gnd inh_gnds inh_vdd inh_vdds) LVT_NADN2x1_PB4_AFBB
    U1162 (n1087 n1088 n1086 inh_gnd inh_gnds inh_vdd inh_vdds) LVT_NADN2x1_PB4_AFBB
    U1166 (bpt_res\<29\> n823 n1090 inh_gnd inh_gnds inh_vdd inh_vdds) LVT_NADN2x1_PB4_AFBB
    U1165 (n1089 n1090 n1085 inh_gnd inh_gnds inh_vdd inh_vdds) LVT_NADN2x1_PB4_AFBB
    U1169 (n840 add_res\<29\> n1092 inh_gnd inh_gnds inh_vdd inh_vdds) LVT_NADN2x1_PB4_AFBB
    U1168 (sra_res\<29\> n807 n1093 inh_gnd inh_gnds inh_vdd inh_vdds) LVT_NADN2x1_PB4_AFBB
    U1167 (n1092 n1093 n1091 inh_gnd inh_gnds inh_vdd inh_vdds) LVT_NADN2x1_PB4_AFBB
    U1151 (sra_res\<2\> n807 n1076 inh_gnd inh_gnds inh_vdd inh_vdds) LVT_NADN2x1_PB4_AFBB
    U1152 (n911 add_res\<2\> n1075 inh_gnd inh_gnds inh_vdd inh_vdds) LVT_NADN2x1_PB4_AFBB
    U1067 (n911 add_res\<5\> n991 inh_gnd inh_gnds inh_vdd inh_vdds) LVT_NADN2x1_PB4_AFBB
    U1150 (n1075 n1076 n1074 inh_gnd inh_gnds inh_vdd inh_vdds) LVT_NADN2x1_PB4_AFBB
    U1149 (bpt_res\<2\> n823 n1073 inh_gnd inh_gnds inh_vdd inh_vdds) LVT_NADN2x1_PB4_AFBB
    U1148 (n1072 n1073 n1068 inh_gnd inh_gnds inh_vdd inh_vdds) LVT_NADN2x1_PB4_AFBB
    U1147 (sll_res\<2\> n801 n1070 inh_gnd inh_gnds inh_vdd inh_vdds) LVT_NADN2x1_PB4_AFBB
    U1146 (sub_res\<2\> n805 n1071 inh_gnd inh_gnds inh_vdd inh_vdds) LVT_NADN2x1_PB4_AFBB
    U1145 (n1070 n1071 n1069 inh_gnd inh_gnds inh_vdd inh_vdds) LVT_NADN2x1_PB4_AFBB
    U1143 (n1066 n1067 n1513 inh_gnd inh_gnds inh_vdd inh_vdds) LVT_NADN2x1_PB4_AFBB
    U1159 (or_res\<2\> n837 n1081 inh_gnd inh_gnds inh_vdd inh_vdds) LVT_NADN2x1_PB4_AFBB
    U1158 (xor_res\<2\> n809 n1082 inh_gnd inh_gnds inh_vdd inh_vdds) LVT_NADN2x1_PB4_AFBB
    U1157 (n1081 n1082 n1077 inh_gnd inh_gnds inh_vdd inh_vdds) LVT_NADN2x1_PB4_AFBB
    U1155 (and_res\<2\> n803 n1080 inh_gnd inh_gnds inh_vdd inh_vdds) LVT_NADN2x1_PB4_AFBB
    U1156 (srl_res\<2\> n849 n1079 inh_gnd inh_gnds inh_vdd inh_vdds) LVT_NADN2x1_PB4_AFBB
    U1154 (n1079 n1080 n1078 inh_gnd inh_gnds inh_vdd inh_vdds) LVT_NADN2x1_PB4_AFBB
    U1066 (sra_res\<5\> n807 n992 inh_gnd inh_gnds inh_vdd inh_vdds) LVT_NADN2x1_PB4_AFBB
    U1065 (n991 n992 n990 inh_gnd inh_gnds inh_vdd inh_vdds) LVT_NADN2x1_PB4_AFBB
    U1064 (bpt_res\<5\> n823 n989 inh_gnd inh_gnds inh_vdd inh_vdds) LVT_NADN2x1_PB4_AFBB
    U1063 (n988 n989 n984 inh_gnd inh_gnds inh_vdd inh_vdds) LVT_NADN2x1_PB4_AFBB
    U1062 (sll_res\<5\> n801 n986 inh_gnd inh_gnds inh_vdd inh_vdds) LVT_NADN2x1_PB4_AFBB
    U1061 (sub_res\<5\> n805 n987 inh_gnd inh_gnds inh_vdd inh_vdds) LVT_NADN2x1_PB4_AFBB
    U1060 (n986 n987 n985 inh_gnd inh_gnds inh_vdd inh_vdds) LVT_NADN2x1_PB4_AFBB
    U1058 (n982 n983 n1510 inh_gnd inh_gnds inh_vdd inh_vdds) LVT_NADN2x1_PB4_AFBB
    U1074 (or_res\<5\> n837 n997 inh_gnd inh_gnds inh_vdd inh_vdds) LVT_NADN2x1_PB4_AFBB
    U1073 (xor_res\<5\> n809 n998 inh_gnd inh_gnds inh_vdd inh_vdds) LVT_NADN2x1_PB4_AFBB
    U1072 (n997 n998 n993 inh_gnd inh_gnds inh_vdd inh_vdds) LVT_NADN2x1_PB4_AFBB
    U1071 (srl_res\<5\> n849 n995 inh_gnd inh_gnds inh_vdd inh_vdds) LVT_NADN2x1_PB4_AFBB
    U1070 (and_res\<5\> n803 n996 inh_gnd inh_gnds inh_vdd inh_vdds) LVT_NADN2x1_PB4_AFBB
    U1069 (n995 n996 n994 inh_gnd inh_gnds inh_vdd inh_vdds) LVT_NADN2x1_PB4_AFBB
    U1142 (or_res\<30\> n837 n1064 inh_gnd inh_gnds inh_vdd inh_vdds) LVT_NADN2x1_PB4_AFBB
    U1141 (xor_res\<30\> n809 n1065 inh_gnd inh_gnds inh_vdd inh_vdds) LVT_NADN2x1_PB4_AFBB
    U1140 (n1064 n1065 n1060 inh_gnd inh_gnds inh_vdd inh_vdds) LVT_NADN2x1_PB4_AFBB
    U1139 (srl_res\<30\> n849 n1062 inh_gnd inh_gnds inh_vdd inh_vdds) LVT_NADN2x1_PB4_AFBB
    U1138 (and_res\<30\> n803 n1063 inh_gnd inh_gnds inh_vdd inh_vdds) LVT_NADN2x1_PB4_AFBB
    U1137 (n1062 n1063 n1061 inh_gnd inh_gnds inh_vdd inh_vdds) LVT_NADN2x1_PB4_AFBB
    U1126 (n1049 n1050 n1485 inh_gnd inh_gnds inh_vdd inh_vdds) LVT_NADN2x1_PB4_AFBB
    U1132 (bpt_res\<30\> n823 n1056 inh_gnd inh_gnds inh_vdd inh_vdds) LVT_NADN2x1_PB4_AFBB
    U1131 (n1055 n1056 n1051 inh_gnd inh_gnds inh_vdd inh_vdds) LVT_NADN2x1_PB4_AFBB
    U1134 (sra_res\<30\> n807 n1059 inh_gnd inh_gnds inh_vdd inh_vdds) LVT_NADN2x1_PB4_AFBB
    U1135 (add_res\<30\> n822 n1058 inh_gnd inh_gnds inh_vdd inh_vdds) LVT_NADN2x1_PB4_AFBB
    U1133 (n1058 n1059 n1057 inh_gnd inh_gnds inh_vdd inh_vdds) LVT_NADN2x1_PB4_AFBB
    U1130 (sll_res\<30\> n801 n1053 inh_gnd inh_gnds inh_vdd inh_vdds) LVT_NADN2x1_PB4_AFBB
    U1129 (sub_res\<30\> n805 n1054 inh_gnd inh_gnds inh_vdd inh_vdds) LVT_NADN2x1_PB4_AFBB
    U1128 (n1054 n1053 n1052 inh_gnd inh_gnds inh_vdd inh_vdds) LVT_NADN2x1_PB4_AFBB
    U1125 (or_res\<31\> n837 n1047 inh_gnd inh_gnds inh_vdd inh_vdds) LVT_NADN2x1_PB4_AFBB
    U1124 (xor_res\<31\> n809 n1048 inh_gnd inh_gnds inh_vdd inh_vdds) LVT_NADN2x1_PB4_AFBB
    U1123 (n1047 n1048 n1043 inh_gnd inh_gnds inh_vdd inh_vdds) LVT_NADN2x1_PB4_AFBB
    U1122 (srl_res\<31\> n849 n1045 inh_gnd inh_gnds inh_vdd inh_vdds) LVT_NADN2x1_PB4_AFBB
    U1121 (and_res\<31\> n803 n1046 inh_gnd inh_gnds inh_vdd inh_vdds) LVT_NADN2x1_PB4_AFBB
    U1120 (n1045 n1046 n1044 inh_gnd inh_gnds inh_vdd inh_vdds) LVT_NADN2x1_PB4_AFBB
    U1109 (n1033 n1034 n1484 inh_gnd inh_gnds inh_vdd inh_vdds) LVT_NADN2x1_PB4_AFBB
    U1115 (bpt_res\<31\> n823 n1039 inh_gnd inh_gnds inh_vdd inh_vdds) LVT_NADN2x1_PB4_AFBB
    U1114 (n810 n1039 n1035 inh_gnd inh_gnds inh_vdd inh_vdds) LVT_NADN2x1_PB4_AFBB
    U1117 (sra_res\<31\> n807 n1042 inh_gnd inh_gnds inh_vdd inh_vdds) LVT_NADN2x1_PB4_AFBB
    U1118 (n912 add_res\<31\> n1041 inh_gnd inh_gnds inh_vdd inh_vdds) LVT_NADN2x1_PB4_AFBB
    U1116 (n1041 n1042 n1040 inh_gnd inh_gnds inh_vdd inh_vdds) LVT_NADN2x1_PB4_AFBB
    U1113 (sll_res\<31\> n801 n1037 inh_gnd inh_gnds inh_vdd inh_vdds) LVT_NADN2x1_PB4_AFBB
    U1112 (sub_res\<31\> n805 n1038 inh_gnd inh_gnds inh_vdd inh_vdds) LVT_NADN2x1_PB4_AFBB
    U1111 (n1038 n1037 n1036 inh_gnd inh_gnds inh_vdd inh_vdds) LVT_NADN2x1_PB4_AFBB
    U1050 (n912 add_res\<6\> n974 inh_gnd inh_gnds inh_vdd inh_vdds) LVT_NADN2x1_PB4_AFBB
    U1049 (sra_res\<6\> n807 n975 inh_gnd inh_gnds inh_vdd inh_vdds) LVT_NADN2x1_PB4_AFBB
    U1046 (n971 n972 n967 inh_gnd inh_gnds inh_vdd inh_vdds) LVT_NADN2x1_PB4_AFBB
    U1047 (bpt_res\<6\> n823 n972 inh_gnd inh_gnds inh_vdd inh_vdds) LVT_NADN2x1_PB4_AFBB
    U1048 (n974 n975 n973 inh_gnd inh_gnds inh_vdd inh_vdds) LVT_NADN2x1_PB4_AFBB
    U1108 (or_res\<3\> n837 n1031 inh_gnd inh_gnds inh_vdd inh_vdds) LVT_NADN2x1_PB4_AFBB
    U1107 (xor_res\<3\> n809 n1032 inh_gnd inh_gnds inh_vdd inh_vdds) LVT_NADN2x1_PB4_AFBB
    U1106 (n1031 n1032 n1027 inh_gnd inh_gnds inh_vdd inh_vdds) LVT_NADN2x1_PB4_AFBB
    U1105 (srl_res\<3\> n849 n1029 inh_gnd inh_gnds inh_vdd inh_vdds) LVT_NADN2x1_PB4_AFBB
    U1104 (and_res\<3\> n803 n1030 inh_gnd inh_gnds inh_vdd inh_vdds) LVT_NADN2x1_PB4_AFBB
    U1103 (n1029 n1030 n1028 inh_gnd inh_gnds inh_vdd inh_vdds) LVT_NADN2x1_PB4_AFBB
    U1092 (n1016 n1017 n1512 inh_gnd inh_gnds inh_vdd inh_vdds) LVT_NADN2x1_PB4_AFBB
    U1098 (bpt_res\<3\> n823 n1023 inh_gnd inh_gnds inh_vdd inh_vdds) LVT_NADN2x1_PB4_AFBB
    U1097 (n1022 n1023 n1018 inh_gnd inh_gnds inh_vdd inh_vdds) LVT_NADN2x1_PB4_AFBB
    U1101 (n819 add_res\<3\> n1025 inh_gnd inh_gnds inh_vdd inh_vdds) LVT_NADN2x1_PB4_AFBB
    U1100 (sra_res\<3\> n807 n1026 inh_gnd inh_gnds inh_vdd inh_vdds) LVT_NADN2x1_PB4_AFBB
    U1099 (n1025 n1026 n1024 inh_gnd inh_gnds inh_vdd inh_vdds) LVT_NADN2x1_PB4_AFBB
    U1096 (sll_res\<3\> n801 n1020 inh_gnd inh_gnds inh_vdd inh_vdds) LVT_NADN2x1_PB4_AFBB
    U1095 (sub_res\<3\> n805 n1021 inh_gnd inh_gnds inh_vdd inh_vdds) LVT_NADN2x1_PB4_AFBB
    U1094 (n1020 n1021 n1019 inh_gnd inh_gnds inh_vdd inh_vdds) LVT_NADN2x1_PB4_AFBB
    U1091 (or_res\<4\> n837 n1014 inh_gnd inh_gnds inh_vdd inh_vdds) LVT_NADN2x1_PB4_AFBB
    U1090 (xor_res\<4\> n809 n1015 inh_gnd inh_gnds inh_vdd inh_vdds) LVT_NADN2x1_PB4_AFBB
    U1089 (n1014 n1015 n1010 inh_gnd inh_gnds inh_vdd inh_vdds) LVT_NADN2x1_PB4_AFBB
    U1088 (srl_res\<4\> n849 n1012 inh_gnd inh_gnds inh_vdd inh_vdds) LVT_NADN2x1_PB4_AFBB
    U1087 (and_res\<4\> n803 n1013 inh_gnd inh_gnds inh_vdd inh_vdds) LVT_NADN2x1_PB4_AFBB
    U1086 (n1012 n1013 n1011 inh_gnd inh_gnds inh_vdd inh_vdds) LVT_NADN2x1_PB4_AFBB
    U1075 (n999 n1000 n1511 inh_gnd inh_gnds inh_vdd inh_vdds) LVT_NADN2x1_PB4_AFBB
    U1081 (bpt_res\<4\> n823 n1006 inh_gnd inh_gnds inh_vdd inh_vdds) LVT_NADN2x1_PB4_AFBB
    U1080 (n1005 n1006 n1001 inh_gnd inh_gnds inh_vdd inh_vdds) LVT_NADN2x1_PB4_AFBB
    U1083 (sra_res\<4\> n807 n1009 inh_gnd inh_gnds inh_vdd inh_vdds) LVT_NADN2x1_PB4_AFBB
    U1084 (n909 add_res\<4\> n1008 inh_gnd inh_gnds inh_vdd inh_vdds) LVT_NADN2x1_PB4_AFBB
    U1082 (n1008 n1009 n1007 inh_gnd inh_gnds inh_vdd inh_vdds) LVT_NADN2x1_PB4_AFBB
    U1079 (sll_res\<4\> n801 n1003 inh_gnd inh_gnds inh_vdd inh_vdds) LVT_NADN2x1_PB4_AFBB
    U1078 (sub_res\<4\> n805 n1004 inh_gnd inh_gnds inh_vdd inh_vdds) LVT_NADN2x1_PB4_AFBB
    U1077 (n1003 n1004 n1002 inh_gnd inh_gnds inh_vdd inh_vdds) LVT_NADN2x1_PB4_AFBB
    U1057 (or_res\<6\> n837 n980 inh_gnd inh_gnds inh_vdd inh_vdds) LVT_NADN2x1_PB4_AFBB
    U1056 (xor_res\<6\> n809 n981 inh_gnd inh_gnds inh_vdd inh_vdds) LVT_NADN2x1_PB4_AFBB
    U1055 (n980 n981 n976 inh_gnd inh_gnds inh_vdd inh_vdds) LVT_NADN2x1_PB4_AFBB
    U1054 (srl_res\<6\> n849 n978 inh_gnd inh_gnds inh_vdd inh_vdds) LVT_NADN2x1_PB4_AFBB
    U1053 (and_res\<6\> n803 n979 inh_gnd inh_gnds inh_vdd inh_vdds) LVT_NADN2x1_PB4_AFBB
    U1052 (n978 n979 n977 inh_gnd inh_gnds inh_vdd inh_vdds) LVT_NADN2x1_PB4_AFBB
    U1041 (n965 n966 n1509 inh_gnd inh_gnds inh_vdd inh_vdds) LVT_NADN2x1_PB4_AFBB
    U1045 (sll_res\<6\> n801 n969 inh_gnd inh_gnds inh_vdd inh_vdds) LVT_NADN2x1_PB4_AFBB
    U1044 (sub_res\<6\> n805 n970 inh_gnd inh_gnds inh_vdd inh_vdds) LVT_NADN2x1_PB4_AFBB
    U1043 (n969 n970 n968 inh_gnd inh_gnds inh_vdd inh_vdds) LVT_NADN2x1_PB4_AFBB
    U1040 (or_res\<7\> n837 n963 inh_gnd inh_gnds inh_vdd inh_vdds) LVT_NADN2x1_PB4_AFBB
    U1039 (xor_res\<7\> n809 n964 inh_gnd inh_gnds inh_vdd inh_vdds) LVT_NADN2x1_PB4_AFBB
    U1038 (n963 n964 n959 inh_gnd inh_gnds inh_vdd inh_vdds) LVT_NADN2x1_PB4_AFBB
    U1037 (srl_res\<7\> n849 n961 inh_gnd inh_gnds inh_vdd inh_vdds) LVT_NADN2x1_PB4_AFBB
    U1036 (and_res\<7\> n803 n962 inh_gnd inh_gnds inh_vdd inh_vdds) LVT_NADN2x1_PB4_AFBB
    U1035 (n961 n962 n960 inh_gnd inh_gnds inh_vdd inh_vdds) LVT_NADN2x1_PB4_AFBB
    U1024 (n948 n949 n1508 inh_gnd inh_gnds inh_vdd inh_vdds) LVT_NADN2x1_PB4_AFBB
    U1030 (bpt_res\<7\> n823 n955 inh_gnd inh_gnds inh_vdd inh_vdds) LVT_NADN2x1_PB4_AFBB
    U1029 (n954 n955 n950 inh_gnd inh_gnds inh_vdd inh_vdds) LVT_NADN2x1_PB4_AFBB
    U1032 (sra_res\<7\> n807 n958 inh_gnd inh_gnds inh_vdd inh_vdds) LVT_NADN2x1_PB4_AFBB
    U1033 (n822 add_res\<7\> n957 inh_gnd inh_gnds inh_vdd inh_vdds) LVT_NADN2x1_PB4_AFBB
    U1031 (n957 n958 n956 inh_gnd inh_gnds inh_vdd inh_vdds) LVT_NADN2x1_PB4_AFBB
    U998 (sra_res\<9\> n807 n924 inh_gnd inh_gnds inh_vdd inh_vdds) LVT_NADN2x1_PB4_AFBB
    U999 (n829 add_res\<9\> n923 inh_gnd inh_gnds inh_vdd inh_vdds) LVT_NADN2x1_PB4_AFBB
    U997 (n923 n924 n922 inh_gnd inh_gnds inh_vdd inh_vdds) LVT_NADN2x1_PB4_AFBB
    U996 (bpt_res\<9\> n823 n921 inh_gnd inh_gnds inh_vdd inh_vdds) LVT_NADN2x1_PB4_AFBB
    U995 (n920 n921 n916 inh_gnd inh_gnds inh_vdd inh_vdds) LVT_NADN2x1_PB4_AFBB
    U1028 (sll_res\<7\> n801 n952 inh_gnd inh_gnds inh_vdd inh_vdds) LVT_NADN2x1_PB4_AFBB
    U1027 (sub_res\<7\> n805 n953 inh_gnd inh_gnds inh_vdd inh_vdds) LVT_NADN2x1_PB4_AFBB
    U1026 (n952 n953 n951 inh_gnd inh_gnds inh_vdd inh_vdds) LVT_NADN2x1_PB4_AFBB
    U994 (sll_res\<9\> n801 n918 inh_gnd inh_gnds inh_vdd inh_vdds) LVT_NADN2x1_PB4_AFBB
    U993 (sub_res\<9\> n805 n919 inh_gnd inh_gnds inh_vdd inh_vdds) LVT_NADN2x1_PB4_AFBB
    U992 (n918 n919 n917 inh_gnd inh_gnds inh_vdd inh_vdds) LVT_NADN2x1_PB4_AFBB
    U1006 (or_res\<9\> n837 n929 inh_gnd inh_gnds inh_vdd inh_vdds) LVT_NADN2x1_PB4_AFBB
    U1004 (n929 n930 n925 inh_gnd inh_gnds inh_vdd inh_vdds) LVT_NADN2x1_PB4_AFBB
    U990 (n914 n915 n1506 inh_gnd inh_gnds inh_vdd inh_vdds) LVT_NADN2x1_PB4_AFBB
    U1007 (n931 n932 n1507 inh_gnd inh_gnds inh_vdd inh_vdds) LVT_NADN2x1_PB4_AFBB
    U1023 (or_res\<8\> n837 n946 inh_gnd inh_gnds inh_vdd inh_vdds) LVT_NADN2x1_PB4_AFBB
    U1022 (xor_res\<8\> n809 n947 inh_gnd inh_gnds inh_vdd inh_vdds) LVT_NADN2x1_PB4_AFBB
    U1021 (n946 n947 n942 inh_gnd inh_gnds inh_vdd inh_vdds) LVT_NADN2x1_PB4_AFBB
    U1005 (xor_res\<9\> n809 n930 inh_gnd inh_gnds inh_vdd inh_vdds) LVT_NADN2x1_PB4_AFBB
    U1020 (srl_res\<8\> n849 n944 inh_gnd inh_gnds inh_vdd inh_vdds) LVT_NADN2x1_PB4_AFBB
    U1019 (and_res\<8\> n803 n945 inh_gnd inh_gnds inh_vdd inh_vdds) LVT_NADN2x1_PB4_AFBB
    U1018 (n944 n945 n943 inh_gnd inh_gnds inh_vdd inh_vdds) LVT_NADN2x1_PB4_AFBB
    U1003 (srl_res\<9\> n849 n927 inh_gnd inh_gnds inh_vdd inh_vdds) LVT_NADN2x1_PB4_AFBB
    U1002 (and_res\<9\> n803 n928 inh_gnd inh_gnds inh_vdd inh_vdds) LVT_NADN2x1_PB4_AFBB
    U1001 (n927 n928 n926 inh_gnd inh_gnds inh_vdd inh_vdds) LVT_NADN2x1_PB4_AFBB
    U1011 (sll_res\<8\> n801 n935 inh_gnd inh_gnds inh_vdd inh_vdds) LVT_NADN2x1_PB4_AFBB
    U1010 (sub_res\<8\> n805 n936 inh_gnd inh_gnds inh_vdd inh_vdds) LVT_NADN2x1_PB4_AFBB
    U1009 (n936 n935 n934 inh_gnd inh_gnds inh_vdd inh_vdds) LVT_NADN2x1_PB4_AFBB
    U873 (n1461 n1460 inh_gnd inh_gnds inh_vdd inh_vdds) LVT_invx2_PB4_AFBB
    U982 (n1442 n1441 inh_gnd inh_gnds inh_vdd inh_vdds) LVT_invx2_PB4_AFBB
    U980 (n1515 n906 inh_gnd inh_gnds inh_vdd inh_vdds) LVT_invx2_PB4_AFBB
    U981 (n906 result\<0\> inh_gnd inh_gnds inh_vdd inh_vdds) LVT_invx2_PB4_AFBB
    U854 (n1452 n1451 inh_gnd inh_gnds inh_vdd inh_vdds) LVT_invx2_PB4_AFBB
    U843 (n1447 n1446 inh_gnd inh_gnds inh_vdd inh_vdds) LVT_invx2_PB4_AFBB
    U876 (operation\<1\> n824 inh_gnd inh_gnds inh_vdd inh_vdds) LVT_invx2_PB4_AFBB
    U850 (operation\<0\> n812 inh_gnd inh_gnds inh_vdd inh_vdds) LVT_invx2_PB4_AFBB
    U966 (n1505 n892 inh_gnd inh_gnds inh_vdd inh_vdds) LVT_invx2_PB4_AFBB
    U967 (n892 result\<10\> inh_gnd inh_gnds inh_vdd inh_vdds) LVT_invx2_PB4_AFBB
    U898 (n1431 n1429 inh_gnd inh_gnds inh_vdd inh_vdds) LVT_invx2_PB4_AFBB
    U964 (n1504 n890 inh_gnd inh_gnds inh_vdd inh_vdds) LVT_invx2_PB4_AFBB
    U965 (n890 result\<11\> inh_gnd inh_gnds inh_vdd inh_vdds) LVT_invx2_PB4_AFBB
    U897 (n1414 n1412 inh_gnd inh_gnds inh_vdd inh_vdds) LVT_invx2_PB4_AFBB
    U962 (n1503 n888 inh_gnd inh_gnds inh_vdd inh_vdds) LVT_invx2_PB4_AFBB
    U963 (n888 result\<12\> inh_gnd inh_gnds inh_vdd inh_vdds) LVT_invx2_PB4_AFBB
    U896 (n1397 n1395 inh_gnd inh_gnds inh_vdd inh_vdds) LVT_invx2_PB4_AFBB
    U960 (n1502 n886 inh_gnd inh_gnds inh_vdd inh_vdds) LVT_invx2_PB4_AFBB
    U961 (n886 result\<13\> inh_gnd inh_gnds inh_vdd inh_vdds) LVT_invx2_PB4_AFBB
    U844 (n1380 n1378 inh_gnd inh_gnds inh_vdd inh_vdds) LVT_invx2_PB4_AFBB
    U862 (operation\<1\> n818 inh_gnd inh_gnds inh_vdd inh_vdds) LVT_invx2_PB4_AFBB
    U906 (n1474 n1475 inh_gnd inh_gnds inh_vdd inh_vdds) LVT_invx2_PB4_AFBB
    U851 (n1471 n813 inh_gnd inh_gnds inh_vdd inh_vdds) LVT_invx2_PB4_AFBB
    U849 (operation\<0\> n811 inh_gnd inh_gnds inh_vdd inh_vdds) LVT_invx2_PB4_AFBB
    U879 (operation\<1\> n827 inh_gnd inh_gnds inh_vdd inh_vdds) LVT_invx2_PB4_AFBB
    U958 (n1501 n884 inh_gnd inh_gnds inh_vdd inh_vdds) LVT_invx2_PB4_AFBB
    U959 (n884 result\<14\> inh_gnd inh_gnds inh_vdd inh_vdds) LVT_invx2_PB4_AFBB
    U895 (n1363 n1361 inh_gnd inh_gnds inh_vdd inh_vdds) LVT_invx2_PB4_AFBB
    U956 (n1500 n882 inh_gnd inh_gnds inh_vdd inh_vdds) LVT_invx2_PB4_AFBB
    U957 (n882 result\<15\> inh_gnd inh_gnds inh_vdd inh_vdds) LVT_invx2_PB4_AFBB
    U894 (n1346 n1344 inh_gnd inh_gnds inh_vdd inh_vdds) LVT_invx2_PB4_AFBB
    U954 (n1499 n880 inh_gnd inh_gnds inh_vdd inh_vdds) LVT_invx2_PB4_AFBB
    U955 (n880 result\<16\> inh_gnd inh_gnds inh_vdd inh_vdds) LVT_invx2_PB4_AFBB
    U869 (n1329 n1327 inh_gnd inh_gnds inh_vdd inh_vdds) LVT_invx2_PB4_AFBB
    U952 (n1498 n878 inh_gnd inh_gnds inh_vdd inh_vdds) LVT_invx2_PB4_AFBB
    U953 (n878 result\<17\> inh_gnd inh_gnds inh_vdd inh_vdds) LVT_invx2_PB4_AFBB
    U868 (n1312 n1310 inh_gnd inh_gnds inh_vdd inh_vdds) LVT_invx2_PB4_AFBB
    U950 (n1497 n876 inh_gnd inh_gnds inh_vdd inh_vdds) LVT_invx2_PB4_AFBB
    U951 (n876 result\<18\> inh_gnd inh_gnds inh_vdd inh_vdds) LVT_invx2_PB4_AFBB
    U848 (n1295 n1293 inh_gnd inh_gnds inh_vdd inh_vdds) LVT_invx2_PB4_AFBB
    U948 (n1496 n874 inh_gnd inh_gnds inh_vdd inh_vdds) LVT_invx2_PB4_AFBB
    U949 (n874 result\<19\> inh_gnd inh_gnds inh_vdd inh_vdds) LVT_invx2_PB4_AFBB
    U858 (n1278 n1276 inh_gnd inh_gnds inh_vdd inh_vdds) LVT_invx2_PB4_AFBB
    U984 (N5 n908 inh_gnd inh_gnds inh_vdd inh_vdds) LVT_invx2_PB4_AFBB
    U853 (n813 n815 inh_gnd inh_gnds inh_vdd inh_vdds) LVT_invx2_PB4_AFBB
    U852 (n813 n814 inh_gnd inh_gnds inh_vdd inh_vdds) LVT_invx2_PB4_AFBB
    U833 (n794 n800 inh_gnd inh_gnds inh_vdd inh_vdds) LVT_invx2_PB4_AFBB
    U834 (n800 n801 inh_gnd inh_gnds inh_vdd inh_vdds) LVT_invx2_PB4_AFBB
    U978 (n1514 n904 inh_gnd inh_gnds inh_vdd inh_vdds) LVT_invx2_PB4_AFBB
    U979 (n904 result\<1\> inh_gnd inh_gnds inh_vdd inh_vdds) LVT_invx2_PB4_AFBB
    U903 (n1261 n1259 inh_gnd inh_gnds inh_vdd inh_vdds) LVT_invx2_PB4_AFBB
    U911 (n831 n841 inh_gnd inh_gnds inh_vdd inh_vdds) LVT_invx2_PB4_AFBB
    U946 (n1495 n872 inh_gnd inh_gnds inh_vdd inh_vdds) LVT_invx2_PB4_AFBB
    U947 (n872 result\<20\> inh_gnd inh_gnds inh_vdd inh_vdds) LVT_invx2_PB4_AFBB
    U867 (n1244 n1242 inh_gnd inh_gnds inh_vdd inh_vdds) LVT_invx2_PB4_AFBB
    U987 (n833 n911 inh_gnd inh_gnds inh_vdd inh_vdds) LVT_invx2_PB4_AFBB
    U944 (n1494 n870 inh_gnd inh_gnds inh_vdd inh_vdds) LVT_invx2_PB4_AFBB
    U945 (n870 result\<21\> inh_gnd inh_gnds inh_vdd inh_vdds) LVT_invx2_PB4_AFBB
    U847 (n1227 n1225 inh_gnd inh_gnds inh_vdd inh_vdds) LVT_invx2_PB4_AFBB
    U909 (n833 n839 inh_gnd inh_gnds inh_vdd inh_vdds) LVT_invx2_PB4_AFBB
    U942 (n1493 n868 inh_gnd inh_gnds inh_vdd inh_vdds) LVT_invx2_PB4_AFBB
    U943 (n868 result\<22\> inh_gnd inh_gnds inh_vdd inh_vdds) LVT_invx2_PB4_AFBB
    U857 (n1210 n1208 inh_gnd inh_gnds inh_vdd inh_vdds) LVT_invx2_PB4_AFBB
    U908 (n831 n838 inh_gnd inh_gnds inh_vdd inh_vdds) LVT_invx2_PB4_AFBB
    U865 (n1159 n1157 inh_gnd inh_gnds inh_vdd inh_vdds) LVT_invx2_PB4_AFBB
    U936 (n1490 n862 inh_gnd inh_gnds inh_vdd inh_vdds) LVT_invx2_PB4_AFBB
    U937 (n862 result\<25\> inh_gnd inh_gnds inh_vdd inh_vdds) LVT_invx2_PB4_AFBB
    U900 (n939 n937 inh_gnd inh_gnds inh_vdd inh_vdds) LVT_invx2_PB4_AFBB
    U887 (n830 n833 inh_gnd inh_gnds inh_vdd inh_vdds) LVT_invx2_PB4_AFBB
    U885 (n830 n831 inh_gnd inh_gnds inh_vdd inh_vdds) LVT_invx2_PB4_AFBB
    U986 (n831 n910 inh_gnd inh_gnds inh_vdd inh_vdds) LVT_invx2_PB4_AFBB
    U861 (operation\<3\> n1478 inh_gnd inh_gnds inh_vdd inh_vdds) LVT_invx2_PB4_AFBB
    U839 (n790 n806 inh_gnd inh_gnds inh_vdd inh_vdds) LVT_invx2_PB4_AFBB
    U840 (n806 n807 inh_gnd inh_gnds inh_vdd inh_vdds) LVT_invx2_PB4_AFBB
    U891 (n1481 n1480 inh_gnd inh_gnds inh_vdd inh_vdds) LVT_invx2_PB4_AFBB
    U859 (operation\<3\> n816 inh_gnd inh_gnds inh_vdd inh_vdds) LVT_invx2_PB4_AFBB
    U890 (n791 n834 inh_gnd inh_gnds inh_vdd inh_vdds) LVT_invx2_PB4_AFBB
    U875 (n834 n823 inh_gnd inh_gnds inh_vdd inh_vdds) LVT_invx2_PB4_AFBB
    U940 (n1492 n866 inh_gnd inh_gnds inh_vdd inh_vdds) LVT_invx2_PB4_AFBB
    U941 (n866 result\<23\> inh_gnd inh_gnds inh_vdd inh_vdds) LVT_invx2_PB4_AFBB
    U866 (n1193 n1191 inh_gnd inh_gnds inh_vdd inh_vdds) LVT_invx2_PB4_AFBB
    U938 (n1491 n864 inh_gnd inh_gnds inh_vdd inh_vdds) LVT_invx2_PB4_AFBB
    U939 (n864 result\<24\> inh_gnd inh_gnds inh_vdd inh_vdds) LVT_invx2_PB4_AFBB
    U856 (n1176 n1174 inh_gnd inh_gnds inh_vdd inh_vdds) LVT_invx2_PB4_AFBB
    U934 (n1489 n860 inh_gnd inh_gnds inh_vdd inh_vdds) LVT_invx2_PB4_AFBB
    U935 (n860 result\<26\> inh_gnd inh_gnds inh_vdd inh_vdds) LVT_invx2_PB4_AFBB
    U846 (n1142 n1140 inh_gnd inh_gnds inh_vdd inh_vdds) LVT_invx2_PB4_AFBB
    U932 (n1488 n858 inh_gnd inh_gnds inh_vdd inh_vdds) LVT_invx2_PB4_AFBB
    U933 (n858 result\<27\> inh_gnd inh_gnds inh_vdd inh_vdds) LVT_invx2_PB4_AFBB
    U864 (n1125 n1123 inh_gnd inh_gnds inh_vdd inh_vdds) LVT_invx2_PB4_AFBB
    U930 (n1487 n856 inh_gnd inh_gnds inh_vdd inh_vdds) LVT_invx2_PB4_AFBB
    U931 (n856 result\<28\> inh_gnd inh_gnds inh_vdd inh_vdds) LVT_invx2_PB4_AFBB
    U855 (n1108 n1106 inh_gnd inh_gnds inh_vdd inh_vdds) LVT_invx2_PB4_AFBB
    U983 (n1465 n1483 inh_gnd inh_gnds inh_vdd inh_vdds) LVT_invx2_PB4_AFBB
    U883 (operation\<1\> n1467 inh_gnd inh_gnds inh_vdd inh_vdds) LVT_invx2_PB4_AFBB
    U919 (n799 n848 inh_gnd inh_gnds inh_vdd inh_vdds) LVT_invx2_PB4_AFBB
    U920 (n848 n849 inh_gnd inh_gnds inh_vdd inh_vdds) LVT_invx2_PB4_AFBB
    U872 (n1483 n821 inh_gnd inh_gnds inh_vdd inh_vdds) LVT_invx2_PB4_AFBB
    U881 (operation\<2\> n1472 inh_gnd inh_gnds inh_vdd inh_vdds) LVT_invx2_PB4_AFBB
    U918 (n814 n1479 inh_gnd inh_gnds inh_vdd inh_vdds) LVT_invx2_PB4_AFBB
    U860 (operation\<3\> n817 inh_gnd inh_gnds inh_vdd inh_vdds) LVT_invx2_PB4_AFBB
    U837 (n792 n804 inh_gnd inh_gnds inh_vdd inh_vdds) LVT_invx2_PB4_AFBB
    U838 (n804 n805 inh_gnd inh_gnds inh_vdd inh_vdds) LVT_invx2_PB4_AFBB
    U889 (n1468 n1464 inh_gnd inh_gnds inh_vdd inh_vdds) LVT_invx2_PB4_AFBB
    U841 (n796 n808 inh_gnd inh_gnds inh_vdd inh_vdds) LVT_invx2_PB4_AFBB
    U842 (n808 n809 inh_gnd inh_gnds inh_vdd inh_vdds) LVT_invx2_PB4_AFBB
    U888 (operation\<0\> n1470 inh_gnd inh_gnds inh_vdd inh_vdds) LVT_invx2_PB4_AFBB
    U878 (operation\<1\> n826 inh_gnd inh_gnds inh_vdd inh_vdds) LVT_invx2_PB4_AFBB
    U989 (n797 n913 inh_gnd inh_gnds inh_vdd inh_vdds) LVT_invx2_PB4_AFBB
    U907 (n913 n837 inh_gnd inh_gnds inh_vdd inh_vdds) LVT_invx2_PB4_AFBB
    U877 (operation\<1\> n825 inh_gnd inh_gnds inh_vdd inh_vdds) LVT_invx2_PB4_AFBB
    U835 (n798 n802 inh_gnd inh_gnds inh_vdd inh_vdds) LVT_invx2_PB4_AFBB
    U836 (n802 n803 inh_gnd inh_gnds inh_vdd inh_vdds) LVT_invx2_PB4_AFBB
    U928 (n1486 n854 inh_gnd inh_gnds inh_vdd inh_vdds) LVT_invx2_PB4_AFBB
    U929 (n854 result\<29\> inh_gnd inh_gnds inh_vdd inh_vdds) LVT_invx2_PB4_AFBB
    U893 (n1091 n1089 inh_gnd inh_gnds inh_vdd inh_vdds) LVT_invx2_PB4_AFBB
    U910 (n820 n840 inh_gnd inh_gnds inh_vdd inh_vdds) LVT_invx2_PB4_AFBB
    U988 (n820 n912 inh_gnd inh_gnds inh_vdd inh_vdds) LVT_invx2_PB4_AFBB
    U870 (n1074 n1072 inh_gnd inh_gnds inh_vdd inh_vdds) LVT_invx2_PB4_AFBB
    U976 (n1513 n902 inh_gnd inh_gnds inh_vdd inh_vdds) LVT_invx2_PB4_AFBB
    U977 (n902 result\<2\> inh_gnd inh_gnds inh_vdd inh_vdds) LVT_invx2_PB4_AFBB
    U923 (n990 n988 inh_gnd inh_gnds inh_vdd inh_vdds) LVT_invx2_PB4_AFBB
    U916 (n1510 n846 inh_gnd inh_gnds inh_vdd inh_vdds) LVT_invx2_PB4_AFBB
    U917 (n846 result\<5\> inh_gnd inh_gnds inh_vdd inh_vdds) LVT_invx2_PB4_AFBB
    U926 (n1485 n852 inh_gnd inh_gnds inh_vdd inh_vdds) LVT_invx2_PB4_AFBB
    U927 (n852 result\<30\> inh_gnd inh_gnds inh_vdd inh_vdds) LVT_invx2_PB4_AFBB
    U892 (n1057 n1055 inh_gnd inh_gnds inh_vdd inh_vdds) LVT_invx2_PB4_AFBB
    U924 (n1484 n850 inh_gnd inh_gnds inh_vdd inh_vdds) LVT_invx2_PB4_AFBB
    U925 (n850 result\<31\> inh_gnd inh_gnds inh_vdd inh_vdds) LVT_invx2_PB4_AFBB
    U845 (n1040 n810 inh_gnd inh_gnds inh_vdd inh_vdds) LVT_invx2_PB4_AFBB
    U922 (n973 n971 inh_gnd inh_gnds inh_vdd inh_vdds) LVT_invx2_PB4_AFBB
    U880 (operation\<2\> n828 inh_gnd inh_gnds inh_vdd inh_vdds) LVT_invx2_PB4_AFBB
    U974 (n1512 n900 inh_gnd inh_gnds inh_vdd inh_vdds) LVT_invx2_PB4_AFBB
    U975 (n900 result\<3\> inh_gnd inh_gnds inh_vdd inh_vdds) LVT_invx2_PB4_AFBB
    U902 (n1024 n1022 inh_gnd inh_gnds inh_vdd inh_vdds) LVT_invx2_PB4_AFBB
    U863 (n908 n819 inh_gnd inh_gnds inh_vdd inh_vdds) LVT_invx2_PB4_AFBB
    U882 (n908 n829 inh_gnd inh_gnds inh_vdd inh_vdds) LVT_invx2_PB4_AFBB
    U972 (n1511 n898 inh_gnd inh_gnds inh_vdd inh_vdds) LVT_invx2_PB4_AFBB
    U973 (n898 result\<4\> inh_gnd inh_gnds inh_vdd inh_vdds) LVT_invx2_PB4_AFBB
    U901 (n1007 n1005 inh_gnd inh_gnds inh_vdd inh_vdds) LVT_invx2_PB4_AFBB
    U985 (n832 n909 inh_gnd inh_gnds inh_vdd inh_vdds) LVT_invx2_PB4_AFBB
    U914 (n1509 n844 inh_gnd inh_gnds inh_vdd inh_vdds) LVT_invx2_PB4_AFBB
    U915 (n844 result\<6\> inh_gnd inh_gnds inh_vdd inh_vdds) LVT_invx2_PB4_AFBB
    U912 (n1508 n842 inh_gnd inh_gnds inh_vdd inh_vdds) LVT_invx2_PB4_AFBB
    U913 (n842 result\<7\> inh_gnd inh_gnds inh_vdd inh_vdds) LVT_invx2_PB4_AFBB
    U921 (n956 n954 inh_gnd inh_gnds inh_vdd inh_vdds) LVT_invx2_PB4_AFBB
    U874 (n832 n822 inh_gnd inh_gnds inh_vdd inh_vdds) LVT_invx2_PB4_AFBB
    U899 (n922 n920 inh_gnd inh_gnds inh_vdd inh_vdds) LVT_invx2_PB4_AFBB
    U968 (n1506 n894 inh_gnd inh_gnds inh_vdd inh_vdds) LVT_invx2_PB4_AFBB
    U969 (n894 result\<9\> inh_gnd inh_gnds inh_vdd inh_vdds) LVT_invx2_PB4_AFBB
    U971 (n896 result\<8\> inh_gnd inh_gnds inh_vdd inh_vdds) LVT_invx2_PB4_AFBB
    U970 (n1507 n896 inh_gnd inh_gnds inh_vdd inh_vdds) LVT_invx2_PB4_AFBB
    U886 (n830 n832 inh_gnd inh_gnds inh_vdd inh_vdds) LVT_invx2_PB4_AFBB
    U884 (n820 n830 inh_gnd inh_gnds inh_vdd inh_vdds) LVT_invx2_PB4_AFBB
    U871 (n829 n820 inh_gnd inh_gnds inh_vdd inh_vdds) LVT_invx2_PB4_AFBB
    U1529 (n1456 n1455 n1440 inh_gnd inh_gnds inh_vdd inh_vdds) LVT_NOR2x1_PB4_AFBB
    U1524 (n1450 n1451 n1443 inh_gnd inh_gnds inh_vdd inh_vdds) LVT_NOR2x1_PB4_AFBB
    U1519 (n1445 n1446 n1444 inh_gnd inh_gnds inh_vdd inh_vdds) LVT_NOR2x1_PB4_AFBB
    U1548 (n1476 n824 n793 inh_gnd inh_gnds inh_vdd inh_vdds) LVT_NOR2x1_PB4_AFBB
    U905 (operation\<2\> operation\<3\> n836 inh_gnd inh_gnds inh_vdd inh_vdds) LVT_NOR2x1_PB4_AFBB
    U1510 (n1434 n1435 n1423 inh_gnd inh_gnds inh_vdd inh_vdds) LVT_NOR2x1_PB4_AFBB
    U1501 (n1426 n1425 n1424 inh_gnd inh_gnds inh_vdd inh_vdds) LVT_NOR2x1_PB4_AFBB
    U1493 (n1417 n1418 n1406 inh_gnd inh_gnds inh_vdd inh_vdds) LVT_NOR2x1_PB4_AFBB
    U1484 (n1409 n1408 n1407 inh_gnd inh_gnds inh_vdd inh_vdds) LVT_NOR2x1_PB4_AFBB
    U1476 (n1400 n1401 n1389 inh_gnd inh_gnds inh_vdd inh_vdds) LVT_NOR2x1_PB4_AFBB
    U1467 (n1392 n1391 n1390 inh_gnd inh_gnds inh_vdd inh_vdds) LVT_NOR2x1_PB4_AFBB
    U1459 (n1383 n1384 n1372 inh_gnd inh_gnds inh_vdd inh_vdds) LVT_NOR2x1_PB4_AFBB
    U1450 (n1374 n1375 n1373 inh_gnd inh_gnds inh_vdd inh_vdds) LVT_NOR2x1_PB4_AFBB
    U1545 (n1473 n818 n795 inh_gnd inh_gnds inh_vdd inh_vdds) LVT_NOR2x1_PB4_AFBB
    U904 (operation\<2\> operation\<3\> n835 inh_gnd inh_gnds inh_vdd inh_vdds) LVT_NOR2x1_PB4_AFBB
    U1559 (operation\<2\> operation\<3\> n1474 inh_gnd inh_gnds inh_vdd inh_vdds) LVT_NOR2x1_PB4_AFBB
    U1442 (n1366 n1367 n1355 inh_gnd inh_gnds inh_vdd inh_vdds) LVT_NOR2x1_PB4_AFBB
    U1433 (n1358 n1357 n1356 inh_gnd inh_gnds inh_vdd inh_vdds) LVT_NOR2x1_PB4_AFBB
    U1425 (n1349 n1350 n1338 inh_gnd inh_gnds inh_vdd inh_vdds) LVT_NOR2x1_PB4_AFBB
    U1416 (n1341 n1340 n1339 inh_gnd inh_gnds inh_vdd inh_vdds) LVT_NOR2x1_PB4_AFBB
    U1408 (n1332 n1333 n1321 inh_gnd inh_gnds inh_vdd inh_vdds) LVT_NOR2x1_PB4_AFBB
    U1399 (n1324 n1323 n1322 inh_gnd inh_gnds inh_vdd inh_vdds) LVT_NOR2x1_PB4_AFBB
    U1391 (n1315 n1316 n1304 inh_gnd inh_gnds inh_vdd inh_vdds) LVT_NOR2x1_PB4_AFBB
    U1382 (n1307 n1306 n1305 inh_gnd inh_gnds inh_vdd inh_vdds) LVT_NOR2x1_PB4_AFBB
    U1374 (n1298 n1299 n1287 inh_gnd inh_gnds inh_vdd inh_vdds) LVT_NOR2x1_PB4_AFBB
    U1365 (n1289 n1290 n1288 inh_gnd inh_gnds inh_vdd inh_vdds) LVT_NOR2x1_PB4_AFBB
    U1357 (n1281 n1282 n1270 inh_gnd inh_gnds inh_vdd inh_vdds) LVT_NOR2x1_PB4_AFBB
    U1348 (n1273 n1272 n1271 inh_gnd inh_gnds inh_vdd inh_vdds) LVT_NOR2x1_PB4_AFBB
    U1547 (n821 n1475 n794 inh_gnd inh_gnds inh_vdd inh_vdds) LVT_NOR2x1_PB4_AFBB
    U1557 (n1475 n815 N5 inh_gnd inh_gnds inh_vdd inh_vdds) LVT_NOR2x1_PB4_AFBB
    U1340 (n1264 n1265 n1253 inh_gnd inh_gnds inh_vdd inh_vdds) LVT_NOR2x1_PB4_AFBB
    U1331 (n1256 n1255 n1254 inh_gnd inh_gnds inh_vdd inh_vdds) LVT_NOR2x1_PB4_AFBB
    U1323 (n1247 n1248 n1236 inh_gnd inh_gnds inh_vdd inh_vdds) LVT_NOR2x1_PB4_AFBB
    U1314 (n1239 n1238 n1237 inh_gnd inh_gnds inh_vdd inh_vdds) LVT_NOR2x1_PB4_AFBB
    U1306 (n1230 n1231 n1219 inh_gnd inh_gnds inh_vdd inh_vdds) LVT_NOR2x1_PB4_AFBB
    U1297 (n1221 n1222 n1220 inh_gnd inh_gnds inh_vdd inh_vdds) LVT_NOR2x1_PB4_AFBB
    U1289 (n1213 n1214 n1202 inh_gnd inh_gnds inh_vdd inh_vdds) LVT_NOR2x1_PB4_AFBB
    U1280 (n1205 n1204 n1203 inh_gnd inh_gnds inh_vdd inh_vdds) LVT_NOR2x1_PB4_AFBB
    U1229 (n1154 n1153 n1152 inh_gnd inh_gnds inh_vdd inh_vdds) LVT_NOR2x1_PB4_AFBB
    U1238 (n1162 n1163 n1151 inh_gnd inh_gnds inh_vdd inh_vdds) LVT_NOR2x1_PB4_AFBB
    U1008 (n934 n933 n932 inh_gnd inh_gnds inh_vdd inh_vdds) LVT_NOR2x1_PB4_AFBB
    U1554 (n1482 n1478 n790 inh_gnd inh_gnds inh_vdd inh_vdds) LVT_NOR2x1_PB4_AFBB
    U1553 (operation\<2\> n821 n1481 inh_gnd inh_gnds inh_vdd inh_vdds) LVT_NOR2x1_PB4_AFBB
    U1552 (n816 n1480 n791 inh_gnd inh_gnds inh_vdd inh_vdds) LVT_NOR2x1_PB4_AFBB
    U1272 (n1196 n1197 n1185 inh_gnd inh_gnds inh_vdd inh_vdds) LVT_NOR2x1_PB4_AFBB
    U1263 (n1188 n1187 n1186 inh_gnd inh_gnds inh_vdd inh_vdds) LVT_NOR2x1_PB4_AFBB
    U1255 (n1179 n1180 n1168 inh_gnd inh_gnds inh_vdd inh_vdds) LVT_NOR2x1_PB4_AFBB
    U1246 (n1171 n1170 n1169 inh_gnd inh_gnds inh_vdd inh_vdds) LVT_NOR2x1_PB4_AFBB
    U1221 (n1145 n1146 n1134 inh_gnd inh_gnds inh_vdd inh_vdds) LVT_NOR2x1_PB4_AFBB
    U1212 (n1136 n1137 n1135 inh_gnd inh_gnds inh_vdd inh_vdds) LVT_NOR2x1_PB4_AFBB
    U1204 (n1128 n1129 n1117 inh_gnd inh_gnds inh_vdd inh_vdds) LVT_NOR2x1_PB4_AFBB
    U1195 (n1120 n1119 n1118 inh_gnd inh_gnds inh_vdd inh_vdds) LVT_NOR2x1_PB4_AFBB
    U1187 (n1111 n1112 n1100 inh_gnd inh_gnds inh_vdd inh_vdds) LVT_NOR2x1_PB4_AFBB
    U1178 (n1103 n1102 n1101 inh_gnd inh_gnds inh_vdd inh_vdds) LVT_NOR2x1_PB4_AFBB
    U1170 (n1094 n1095 n1083 inh_gnd inh_gnds inh_vdd inh_vdds) LVT_NOR2x1_PB4_AFBB
    U1538 (n821 n1464 n799 inh_gnd inh_gnds inh_vdd inh_vdds) LVT_NOR2x1_PB4_AFBB
    U1550 (n1477 n817 n792 inh_gnd inh_gnds inh_vdd inh_vdds) LVT_NOR2x1_PB4_AFBB
    U1543 (n814 n1464 n796 inh_gnd inh_gnds inh_vdd inh_vdds) LVT_NOR2x1_PB4_AFBB
    U1541 (n1469 n826 n797 inh_gnd inh_gnds inh_vdd inh_vdds) LVT_NOR2x1_PB4_AFBB
    U1539 (n1466 n825 n798 inh_gnd inh_gnds inh_vdd inh_vdds) LVT_NOR2x1_PB4_AFBB
    U1161 (n1086 n1085 n1084 inh_gnd inh_gnds inh_vdd inh_vdds) LVT_NOR2x1_PB4_AFBB
    U1144 (n1069 n1068 n1067 inh_gnd inh_gnds inh_vdd inh_vdds) LVT_NOR2x1_PB4_AFBB
    U1153 (n1077 n1078 n1066 inh_gnd inh_gnds inh_vdd inh_vdds) LVT_NOR2x1_PB4_AFBB
    U1059 (n985 n984 n983 inh_gnd inh_gnds inh_vdd inh_vdds) LVT_NOR2x1_PB4_AFBB
    U1068 (n993 n994 n982 inh_gnd inh_gnds inh_vdd inh_vdds) LVT_NOR2x1_PB4_AFBB
    U1136 (n1060 n1061 n1049 inh_gnd inh_gnds inh_vdd inh_vdds) LVT_NOR2x1_PB4_AFBB
    U1127 (n1052 n1051 n1050 inh_gnd inh_gnds inh_vdd inh_vdds) LVT_NOR2x1_PB4_AFBB
    U1119 (n1043 n1044 n1033 inh_gnd inh_gnds inh_vdd inh_vdds) LVT_NOR2x1_PB4_AFBB
    U1110 (n1035 n1036 n1034 inh_gnd inh_gnds inh_vdd inh_vdds) LVT_NOR2x1_PB4_AFBB
    U1544 (n828 operation\<3\> n1468 inh_gnd inh_gnds inh_vdd inh_vdds) LVT_NOR2x1_PB4_AFBB
    U1102 (n1027 n1028 n1016 inh_gnd inh_gnds inh_vdd inh_vdds) LVT_NOR2x1_PB4_AFBB
    U1093 (n1019 n1018 n1017 inh_gnd inh_gnds inh_vdd inh_vdds) LVT_NOR2x1_PB4_AFBB
    U1085 (n1010 n1011 n999 inh_gnd inh_gnds inh_vdd inh_vdds) LVT_NOR2x1_PB4_AFBB
    U1076 (n1002 n1001 n1000 inh_gnd inh_gnds inh_vdd inh_vdds) LVT_NOR2x1_PB4_AFBB
    U1051 (n976 n977 n965 inh_gnd inh_gnds inh_vdd inh_vdds) LVT_NOR2x1_PB4_AFBB
    U1042 (n968 n967 n966 inh_gnd inh_gnds inh_vdd inh_vdds) LVT_NOR2x1_PB4_AFBB
    U1034 (n959 n960 n948 inh_gnd inh_gnds inh_vdd inh_vdds) LVT_NOR2x1_PB4_AFBB
    U1025 (n951 n950 n949 inh_gnd inh_gnds inh_vdd inh_vdds) LVT_NOR2x1_PB4_AFBB
    U991 (n917 n916 n915 inh_gnd inh_gnds inh_vdd inh_vdds) LVT_NOR2x1_PB4_AFBB
    U1000 (n925 n926 n914 inh_gnd inh_gnds inh_vdd inh_vdds) LVT_NOR2x1_PB4_AFBB
    U1017 (n942 n943 n931 inh_gnd inh_gnds inh_vdd inh_vdds) LVT_NOR2x1_PB4_AFBB
    alu_add (n822 A\<31\> A\<30\> A\<29\> A\<28\> A\<27\> A\<26\> A\<25\> A\<24\> A\<23\> A\<22\> A\<21\> A\<20\> A\<19\> A\<18\> A\<17\> A\<16\> A\<15\> A\<14\> A\<13\> A\<12\> A\<11\> A\<10\> A\<9\> A\<8\> A\<7\> A\<6\> A\<5\> A\<4\> A\<3\> A\<2\> A\<1\> A\<0\> B\<31\> B\<30\> B\<29\> B\<28\> B\<27\> B\<26\> B\<25\> B\<24\> B\<23\> B\<22\> B\<21\> B\<20\> B\<19\> B\<18\> B\<17\> B\<16\> B\<15\> B\<14\> B\<13\> B\<12\> B\<11\> B\<10\> B\<9\> B\<8\> B\<7\> B\<6\> B\<5\> B\<4\> B\<3\> B\<2\> B\<1\> B\<0\> add_res\<31\> add_res\<30\> add_res\<29\> add_res\<28\> add_res\<27\> add_res\<26\> add_res\<25\> add_res\<24\> add_res\<23\> add_res\<22\> add_res\<21\> add_res\<20\> add_res\<19\> add_res\<18\> add_res\<17\> add_res\<16\> add_res\<15\> add_res\<14\> add_res\<13\> add_res\<12\> add_res\<11\> add_res\<10\> add_res\<9\> add_res\<8\> add_res\<7\> add_res\<6\> add_res\<5\> add_res\<4\> add_res\<3\> add_res\<2\> add_res\<1\> add_res\<0\> inh_gnd inh_gnds inh_vdd inh_vdds) alu_adder
    alu_sub (n805 A\<31\> A\<30\> A\<29\> A\<28\> A\<27\> A\<26\> A\<25\> A\<24\> A\<23\> A\<22\> A\<21\> A\<20\> A\<19\> A\<18\> A\<17\> A\<16\> A\<15\> A\<14\> A\<13\> A\<12\> A\<11\> A\<10\> A\<9\> A\<8\> A\<7\> A\<6\> A\<5\> A\<4\> A\<3\> A\<2\> A\<1\> A\<0\> B\<31\> B\<30\> B\<29\> B\<28\> B\<27\> B\<26\> B\<25\> B\<24\> B\<23\> B\<22\> B\<21\> B\<20\> B\<19\> B\<18\> B\<17\> B\<16\> B\<15\> B\<14\> B\<13\> B\<12\> B\<11\> B\<10\> B\<9\> B\<8\> B\<7\> B\<6\> B\<5\> B\<4\> B\<3\> B\<2\> B\<1\> B\<0\> sub_res\<31\> sub_res\<30\> sub_res\<29\> sub_res\<28\> sub_res\<27\> sub_res\<26\> sub_res\<25\> sub_res\<24\> sub_res\<23\> sub_res\<22\> sub_res\<21\> sub_res\<20\> sub_res\<19\> sub_res\<18\> sub_res\<17\> sub_res\<16\> sub_res\<15\> sub_res\<14\> sub_res\<13\> sub_res\<12\> sub_res\<11\> sub_res\<10\> sub_res\<9\> sub_res\<8\> sub_res\<7\> sub_res\<6\> sub_res\<5\> sub_res\<4\> sub_res\<3\> sub_res\<2\> sub_res\<1\> sub_res\<0\> inh_gnd inh_gnds inh_vdd inh_vdds) alu_subtractor
    alu_and (n803 A\<31\> A\<30\> A\<29\> A\<28\> A\<27\> A\<26\> A\<25\> A\<24\> A\<23\> A\<22\> A\<21\> A\<20\> A\<19\> A\<18\> A\<17\> A\<16\> A\<15\> A\<14\> A\<13\> A\<12\> A\<11\> A\<10\> A\<9\> A\<8\> A\<7\> A\<6\> A\<5\> A\<4\> A\<3\> A\<2\> A\<1\> A\<0\> B\<31\> B\<30\> B\<29\> B\<28\> B\<27\> B\<26\> B\<25\> B\<24\> B\<23\> B\<22\> B\<21\> B\<20\> B\<19\> B\<18\> B\<17\> B\<16\> B\<15\> B\<14\> B\<13\> B\<12\> B\<11\> B\<10\> B\<9\> B\<8\> B\<7\> B\<6\> B\<5\> B\<4\> B\<3\> B\<2\> B\<1\> B\<0\> and_res\<31\> and_res\<30\> and_res\<29\> and_res\<28\> and_res\<27\> and_res\<26\> and_res\<25\> and_res\<24\> and_res\<23\> and_res\<22\> and_res\<21\> and_res\<20\> and_res\<19\> and_res\<18\> and_res\<17\> and_res\<16\> and_res\<15\> and_res\<14\> and_res\<13\> and_res\<12\> and_res\<11\> and_res\<10\> and_res\<9\> and_res\<8\> and_res\<7\> and_res\<6\> and_res\<5\> and_res\<4\> and_res\<3\> and_res\<2\> and_res\<1\> and_res\<0\> inh_gnd inh_gnds inh_vdd inh_vdds) alu_and
    alu_or (n837 A\<31\> A\<30\> A\<29\> A\<28\> A\<27\> A\<26\> A\<25\> A\<24\> A\<23\> A\<22\> A\<21\> A\<20\> A\<19\> A\<18\> A\<17\> A\<16\> A\<15\> A\<14\> A\<13\> A\<12\> A\<11\> A\<10\> A\<9\> A\<8\> A\<7\> A\<6\> A\<5\> A\<4\> A\<3\> A\<2\> A\<1\> A\<0\> B\<31\> B\<30\> B\<29\> B\<28\> B\<27\> B\<26\> B\<25\> B\<24\> B\<23\> B\<22\> B\<21\> B\<20\> B\<19\> B\<18\> B\<17\> B\<16\> B\<15\> B\<14\> B\<13\> B\<12\> B\<11\> B\<10\> B\<9\> B\<8\> B\<7\> B\<6\> B\<5\> B\<4\> B\<3\> B\<2\> B\<1\> B\<0\> or_res\<31\> or_res\<30\> or_res\<29\> or_res\<28\> or_res\<27\> or_res\<26\> or_res\<25\> or_res\<24\> or_res\<23\> or_res\<22\> or_res\<21\> or_res\<20\> or_res\<19\> or_res\<18\> or_res\<17\> or_res\<16\> or_res\<15\> or_res\<14\> or_res\<13\> or_res\<12\> or_res\<11\> or_res\<10\> or_res\<9\> or_res\<8\> or_res\<7\> or_res\<6\> or_res\<5\> or_res\<4\> or_res\<3\> or_res\<2\> or_res\<1\> or_res\<0\> inh_gnd inh_gnds inh_vdd inh_vdds) alu_or
    alu_xor (n809 A\<31\> A\<30\> A\<29\> A\<28\> A\<27\> A\<26\> A\<25\> A\<24\> A\<23\> A\<22\> A\<21\> A\<20\> A\<19\> A\<18\> A\<17\> A\<16\> A\<15\> A\<14\> A\<13\> A\<12\> A\<11\> A\<10\> A\<9\> A\<8\> A\<7\> A\<6\> A\<5\> A\<4\> A\<3\> A\<2\> A\<1\> A\<0\> B\<31\> B\<30\> B\<29\> B\<28\> B\<27\> B\<26\> B\<25\> B\<24\> B\<23\> B\<22\> B\<21\> B\<20\> B\<19\> B\<18\> B\<17\> B\<16\> B\<15\> B\<14\> B\<13\> B\<12\> B\<11\> B\<10\> B\<9\> B\<8\> B\<7\> B\<6\> B\<5\> B\<4\> B\<3\> B\<2\> B\<1\> B\<0\> xor_res\<31\> xor_res\<30\> xor_res\<29\> xor_res\<28\> xor_res\<27\> xor_res\<26\> xor_res\<25\> xor_res\<24\> xor_res\<23\> xor_res\<22\> xor_res\<21\> xor_res\<20\> xor_res\<19\> xor_res\<18\> xor_res\<17\> xor_res\<16\> xor_res\<15\> xor_res\<14\> xor_res\<13\> xor_res\<12\> xor_res\<11\> xor_res\<10\> xor_res\<9\> xor_res\<8\> xor_res\<7\> xor_res\<6\> xor_res\<5\> xor_res\<4\> xor_res\<3\> xor_res\<2\> xor_res\<1\> xor_res\<0\> inh_gnd inh_gnds inh_vdd inh_vdds) alu_xor
    alu_sll (n801 A\<31\> A\<30\> A\<29\> A\<28\> A\<27\> A\<26\> A\<25\> A\<24\> A\<23\> A\<22\> A\<21\> A\<20\> A\<19\> A\<18\> A\<17\> A\<16\> A\<15\> A\<14\> A\<13\> A\<12\> A\<11\> A\<10\> A\<9\> A\<8\> A\<7\> A\<6\> A\<5\> A\<4\> A\<3\> A\<2\> A\<1\> A\<0\> B\<4\> B\<3\> B\<2\> B\<1\> B\<0\> sll_res\<31\> sll_res\<30\> sll_res\<29\> sll_res\<28\> sll_res\<27\> sll_res\<26\> sll_res\<25\> sll_res\<24\> sll_res\<23\> sll_res\<22\> sll_res\<21\> sll_res\<20\> sll_res\<19\> sll_res\<18\> sll_res\<17\> sll_res\<16\> sll_res\<15\> sll_res\<14\> sll_res\<13\> sll_res\<12\> sll_res\<11\> sll_res\<10\> sll_res\<9\> sll_res\<8\> sll_res\<7\> sll_res\<6\> sll_res\<5\> sll_res\<4\> sll_res\<3\> sll_res\<2\> sll_res\<1\> sll_res\<0\> inh_gnd inh_gnds inh_vdd inh_vdds) alu_sll
    alu_sra (n807 A\<31\> A\<30\> A\<29\> A\<28\> A\<27\> A\<26\> A\<25\> A\<24\> A\<23\> A\<22\> A\<21\> A\<20\> A\<19\> A\<18\> A\<17\> A\<16\> A\<15\> A\<14\> A\<13\> A\<12\> A\<11\> A\<10\> A\<9\> A\<8\> A\<7\> A\<6\> A\<5\> A\<4\> A\<3\> A\<2\> A\<1\> A\<0\> B\<4\> B\<3\> B\<2\> B\<1\> B\<0\> sra_res\<31\> sra_res\<30\> sra_res\<29\> sra_res\<28\> sra_res\<27\> sra_res\<26\> sra_res\<25\> sra_res\<24\> sra_res\<23\> sra_res\<22\> sra_res\<21\> sra_res\<20\> sra_res\<19\> sra_res\<18\> sra_res\<17\> sra_res\<16\> sra_res\<15\> sra_res\<14\> sra_res\<13\> sra_res\<12\> sra_res\<11\> sra_res\<10\> sra_res\<9\> sra_res\<8\> sra_res\<7\> sra_res\<6\> sra_res\<5\> sra_res\<4\> sra_res\<3\> sra_res\<2\> sra_res\<1\> sra_res\<0\> inh_gnd inh_gnds inh_vdd inh_vdds) alu_sra
    alu_srl (n849 A\<31\> A\<30\> A\<29\> A\<28\> A\<27\> A\<26\> A\<25\> A\<24\> A\<23\> A\<22\> A\<21\> A\<20\> A\<19\> A\<18\> A\<17\> A\<16\> A\<15\> A\<14\> A\<13\> A\<12\> A\<11\> A\<10\> A\<9\> A\<8\> A\<7\> A\<6\> A\<5\> A\<4\> A\<3\> A\<2\> A\<1\> A\<0\> B\<4\> B\<3\> B\<2\> B\<1\> B\<0\> srl_res\<31\> srl_res\<30\> srl_res\<29\> srl_res\<28\> srl_res\<27\> srl_res\<26\> srl_res\<25\> srl_res\<24\> srl_res\<23\> srl_res\<22\> srl_res\<21\> srl_res\<20\> srl_res\<19\> srl_res\<18\> srl_res\<17\> srl_res\<16\> srl_res\<15\> srl_res\<14\> srl_res\<13\> srl_res\<12\> srl_res\<11\> srl_res\<10\> srl_res\<9\> srl_res\<8\> srl_res\<7\> srl_res\<6\> srl_res\<5\> srl_res\<4\> srl_res\<3\> srl_res\<2\> srl_res\<1\> srl_res\<0\> inh_gnd inh_gnds inh_vdd inh_vdds) alu_srl
    alu_bpt (n823 B\<31\> B\<30\> B\<29\> B\<28\> B\<27\> B\<26\> B\<25\> B\<24\> B\<23\> B\<22\> B\<21\> B\<20\> B\<19\> B\<18\> B\<17\> B\<16\> B\<15\> B\<14\> B\<13\> B\<12\> B\<11\> B\<10\> B\<9\> B\<8\> B\<7\> B\<6\> B\<5\> B\<4\> B\<3\> B\<2\> B\<1\> B\<0\> bpt_res\<31\> bpt_res\<30\> bpt_res\<29\> bpt_res\<28\> bpt_res\<27\> bpt_res\<26\> bpt_res\<25\> bpt_res\<24\> bpt_res\<23\> bpt_res\<22\> bpt_res\<21\> bpt_res\<20\> bpt_res\<19\> bpt_res\<18\> bpt_res\<17\> bpt_res\<16\> bpt_res\<15\> bpt_res\<14\> bpt_res\<13\> bpt_res\<12\> bpt_res\<11\> bpt_res\<10\> bpt_res\<9\> bpt_res\<8\> bpt_res\<7\> bpt_res\<6\> bpt_res\<5\> bpt_res\<4\> bpt_res\<3\> bpt_res\<2\> bpt_res\<1\> bpt_res\<0\>) alu_bpt
    alu_slt (n793 A\<31\> A\<30\> A\<29\> A\<28\> A\<27\> A\<26\> A\<25\> A\<24\> A\<23\> A\<22\> A\<21\> A\<20\> A\<19\> A\<18\> A\<17\> A\<16\> A\<15\> A\<14\> A\<13\> A\<12\> A\<11\> A\<10\> A\<9\> A\<8\> A\<7\> A\<6\> A\<5\> A\<4\> A\<3\> A\<2\> A\<1\> A\<0\> B\<31\> B\<30\> B\<29\> B\<28\> B\<27\> B\<26\> B\<25\> B\<24\> B\<23\> B\<22\> B\<21\> B\<20\> B\<19\> B\<18\> B\<17\> B\<16\> B\<15\> B\<14\> B\<13\> B\<12\> B\<11\> B\<10\> B\<9\> B\<8\> B\<7\> B\<6\> B\<5\> B\<4\> B\<3\> B\<2\> B\<1\> B\<0\> SYNOPSYS_UNCONNECTED__0 SYNOPSYS_UNCONNECTED__1 SYNOPSYS_UNCONNECTED__2 SYNOPSYS_UNCONNECTED__3 SYNOPSYS_UNCONNECTED__4 SYNOPSYS_UNCONNECTED__5 SYNOPSYS_UNCONNECTED__6 SYNOPSYS_UNCONNECTED__7 SYNOPSYS_UNCONNECTED__8 SYNOPSYS_UNCONNECTED__9 SYNOPSYS_UNCONNECTED__10 SYNOPSYS_UNCONNECTED__11 SYNOPSYS_UNCONNECTED__12 SYNOPSYS_UNCONNECTED__13 SYNOPSYS_UNCONNECTED__14 SYNOPSYS_UNCONNECTED__15 SYNOPSYS_UNCONNECTED__16 SYNOPSYS_UNCONNECTED__17 SYNOPSYS_UNCONNECTED__18 SYNOPSYS_UNCONNECTED__19 SYNOPSYS_UNCONNECTED__20 SYNOPSYS_UNCONNECTED__21 SYNOPSYS_UNCONNECTED__22 SYNOPSYS_UNCONNECTED__23 SYNOPSYS_UNCONNECTED__24 SYNOPSYS_UNCONNECTED__25 SYNOPSYS_UNCONNECTED__26 SYNOPSYS_UNCONNECTED__27 SYNOPSYS_UNCONNECTED__28 SYNOPSYS_UNCONNECTED__29 SYNOPSYS_UNCONNECTED__30 slt_res\[0\] inh_gnd inh_gnds inh_vdd inh_vdds) alu_slt
    alu_sltu (n795 A\<31\> A\<30\> A\<29\> A\<28\> A\<27\> A\<26\> A\<25\> A\<24\> A\<23\> A\<22\> A\<21\> A\<20\> A\<19\> A\<18\> A\<17\> A\<16\> A\<15\> A\<14\> A\<13\> A\<12\> A\<11\> A\<10\> A\<9\> A\<8\> A\<7\> A\<6\> A\<5\> A\<4\> A\<3\> A\<2\> A\<1\> A\<0\> B\<31\> B\<30\> B\<29\> B\<28\> B\<27\> B\<26\> B\<25\> B\<24\> B\<23\> B\<22\> B\<21\> B\<20\> B\<19\> B\<18\> B\<17\> B\<16\> B\<15\> B\<14\> B\<13\> B\<12\> B\<11\> B\<10\> B\<9\> B\<8\> B\<7\> B\<6\> B\<5\> B\<4\> B\<3\> B\<2\> B\<1\> B\<0\> SYNOPSYS_UNCONNECTED__31 SYNOPSYS_UNCONNECTED__32 SYNOPSYS_UNCONNECTED__33 SYNOPSYS_UNCONNECTED__34 SYNOPSYS_UNCONNECTED__35 SYNOPSYS_UNCONNECTED__36 SYNOPSYS_UNCONNECTED__37 SYNOPSYS_UNCONNECTED__38 SYNOPSYS_UNCONNECTED__39 SYNOPSYS_UNCONNECTED__40 SYNOPSYS_UNCONNECTED__41 SYNOPSYS_UNCONNECTED__42 SYNOPSYS_UNCONNECTED__43 SYNOPSYS_UNCONNECTED__44 SYNOPSYS_UNCONNECTED__45 SYNOPSYS_UNCONNECTED__46 SYNOPSYS_UNCONNECTED__47 SYNOPSYS_UNCONNECTED__48 SYNOPSYS_UNCONNECTED__49 SYNOPSYS_UNCONNECTED__50 SYNOPSYS_UNCONNECTED__51 SYNOPSYS_UNCONNECTED__52 SYNOPSYS_UNCONNECTED__53 SYNOPSYS_UNCONNECTED__54 SYNOPSYS_UNCONNECTED__55 SYNOPSYS_UNCONNECTED__56 SYNOPSYS_UNCONNECTED__57 SYNOPSYS_UNCONNECTED__58 SYNOPSYS_UNCONNECTED__59 SYNOPSYS_UNCONNECTED__60 SYNOPSYS_UNCONNECTED__61 sltu_res\[0\] inh_gnd inh_gnds inh_vdd inh_vdds) alu_sltu
    V3 (0 inh_gnd) vsource dc=0 type=dc
    V2 (inh_gnds inh_gnd) vsource dc=0 type=dc
    V1 (inh_vdds inh_gnd) vsource dc=-400m type=dc
    V0 (inh_vdd inh_gnd) vsource dc=350m type=dc
ends alu
